`include "constants.vams"
`include "disciplines.vams"

module dac_therm_16b (din_therm, rst_n, vout);
    input [15:0] din_therm;
    input rst_n;
    output vout;
    electrical [15:0] din_therm;
    electrical rst_n;
    electrical vout;

    parameter real vstep = 1.0 from [0:inf);
    parameter real tr = 1n from (0:inf);
    parameter real tf = 1n from (0:inf);

    integer count;
    real vout_val;

    analog begin
        @(initial_step) begin
            count = 0;
            vout_val = 0.0;
        end

        // Count ones in thermometer code - unrolled fixed-index reads
        count = 0;
        if (V(din_therm[0]) > 0.5) count = count + 1;
        if (V(din_therm[1]) > 0.5) count = count + 1;
        if (V(din_therm[2]) > 0.5) count = count + 1;
        if (V(din_therm[3]) > 0.5) count = count + 1;
        if (V(din_therm[4]) > 0.5) count = count + 1;
        if (V(din_therm[5]) > 0.5) count = count + 1;
        if (V(din_therm[6]) > 0.5) count = count + 1;
        if (V(din_therm[7]) > 0.5) count = count + 1;
        if (V(din_therm[8]) > 0.5) count = count + 1;
        if (V(din_therm[9]) > 0.5) count = count + 1;
        if (V(din_therm[10]) > 0.5) count = count + 1;
        if (V(din_therm[11]) > 0.5) count = count + 1;
        if (V(din_therm[12]) > 0.5) count = count + 1;
        if (V(din_therm[13]) > 0.5) count = count + 1;
        if (V(din_therm[14]) > 0.5) count = count + 1;
        if (V(din_therm[15]) > 0.5) count = count + 1;

        // Calculate output voltage based on reset and count
        if (V(rst_n) < 0.5) begin
            vout_val = 0.0;
        end else begin
            vout_val = count * vstep;
        end

        // Drive output with transition
        V(vout) <+ transition(vout_val, 0, tr, tf);
    end
endmodule
