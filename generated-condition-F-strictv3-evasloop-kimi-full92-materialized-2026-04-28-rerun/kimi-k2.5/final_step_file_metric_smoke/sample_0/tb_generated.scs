simulator lang=spectre
global 0

ahdl_include "final_step_file_metric_ref.va"

// Power supplies
VDD (VDD 0) vsource dc=1.8
VSS (VSS 0) vsource dc=0

// Reference clock input - generate some edges
Vref (ref 0) vsource type=pulse val0=0 val1=1.8 period=10n rise=100p fall=100p width=5n

// DUT instance
XDUT (VDD VSS ref metric_out) final_step_file_metric_ref

// Transient analysis
tran tran stop=80n maxstep=20p errpreset=conservative

// Save statements for required observables
save ref
save metric_out
