`include "constants.vams"
`include "disciplines.vams"

module clk_burst_gen (CLK, RST_N, CLK_OUT);
    input CLK;
    input RST_N;
    output CLK_OUT;
    electrical CLK, RST_N, CLK_OUT;

    parameter integer div = 8 from [3:inf);
    parameter real vhi = 1.8;
    parameter real vlo = 0.0;
    parameter real vth = 0.9;
    parameter real tt = 1n;

    integer counter;
    integer burst_active;
    real out_val;

    analog begin
        @(initial_step) begin
            counter = 0;
            burst_active = 0;
            out_val = vlo;
        end

        // Reset handling - active low
        @(cross(V(RST_N) - vth, -1)) begin
            counter = 0;
            burst_active = 0;
            out_val = vlo;
        end

        // Clock rising edge detection
        @(cross(V(CLK) - vth, 1)) begin
            if (V(RST_N) > vth) begin
                // Reset deasserted, normal operation
                if (counter < 2) begin
                    // First 2 cycles: burst active, output follows clock (will be high on rising edge)
                    burst_active = 1;
                    out_val = vhi;
                end else begin
                    // After 2 cycles: burst inactive, output low
                    burst_active = 0;
                    out_val = vlo;
                end

                counter = counter + 1;
                if (counter >= div) begin
                    counter = 0;
                end
            end
        end

        // Clock falling edge detection
        @(cross(V(CLK) - vth, -1)) begin
            if (V(RST_N) > vth) begin
                if (burst_active == 1) begin
                    // During burst, output follows clock (low on falling edge)
                    out_val = vlo;
                end
                // else: already low, stay low
            end
        end

        V(CLK_OUT) <+ transition(out_val, 0, tt);
    end
endmodule
