simulator lang=spectre
global 0

ahdl_include "gray_counter_4b.va"

// Power supplies
Vdd (vdd 0) vsource dc=1.8
Vss (vss 0) vsource dc=0

// Clock: 100MHz (10ns period), 50% duty cycle
Vclk (clk 0) vsource type=pulse val0=0 val1=1.8 period=10n rise=100p fall=100p width=5n

// Enable: high after initial reset
Ven (en 0) vsource type=pwl wave=[0 0 50n 0 60n 1.8]

// Reset: active-low, assert at start then release
Vrstb (rstb 0) vsource type=pwl wave=[0 0 20n 0 30n 1.8]

// DUT instance
XDUT (vdd vss clk en rstb g3 g2 g1 g0) gray_counter_4b

// Save signals
save clk rstb g3 g2 g1 g0

// Transient analysis
tran tran stop=2u maxstep=500p errpreset=conservative
