simulator lang=spectre
global 0

ahdl_include "transition_branch_target_ref.va"

// Power supplies
VDD (VDD 0) vsource dc=1.8
VSS (VSS 0) vsource dc=0

// Clock: 10MHz, 50% duty cycle, 100ps rise/fall
Vclk (clk 0) vsource type=pulse val0=0 val1=1.8 period=100n rise=100p fall=100p width=50n

// Mode signal: changes at specific times
Vmode (mode 0) vsource type=pwl wave=[0n 0, 25n 0, 25.1n 1.8, 65n 1.8, 65.1n 0, 90n 0]

// DUT instance
XDUT (mode clk out VDD VSS) transition_branch_target_ref

// Analysis
tran tran stop=90n maxstep=20p errpreset=conservative

// Save signals
save mode clk out
