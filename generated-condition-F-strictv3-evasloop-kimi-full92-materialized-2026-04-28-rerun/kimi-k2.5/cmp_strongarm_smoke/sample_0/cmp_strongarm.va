`include "constants.vams"
`include "disciplines.vams"

module cmp_strongarm (clk, vinn, vinp, out_n, out_p, lp, lm, vss, vdd);
    input clk;
    input vinn;
    input vinp;
    output out_n;
    output out_p;
    output lp;
    output lm;
    inout vss;
    inout vdd;
    electrical clk, vinn, vinp, out_n, out_p, lp, lm, vss, vdd;

    parameter real vth = 0.45 from (0:inf);
    parameter real tr = 50p from (0:inf);
    parameter real tf = 50p from (0:inf);
    parameter real td = 100p from [0:inf);

    integer state;
    real vhi;
    real vlo;
    real out_p_target;
    real out_n_target;
    real lp_target;
    real lm_target;

    analog begin
        @(initial_step) begin
            state = 0;
        end

        vhi = V(vdd);
        vlo = V(vss);

        @(cross(V(clk) - vth, 1)) begin
            if (V(vinp) > V(vinn)) begin
                state = 1;
            end else begin
                state = -1;
            end
        end

        if (state == 1) begin
            out_p_target = vhi;
            out_n_target = vlo;
            lp_target = vhi;
            lm_target = vlo;
        end else if (state == -1) begin
            out_p_target = vlo;
            out_n_target = vhi;
            lp_target = vlo;
            lm_target = vhi;
        end else begin
            out_p_target = (vhi+vlo)/2;
            out_n_target = (vhi+vlo)/2;
            lp_target = (vhi+vlo)/2;
            lm_target = (vhi+vlo)/2;
        end

        V(out_p) <+ transition(out_p_target, td, tr, tf);
        V(out_n) <+ transition(out_n_target, td, tr, tf);
        V(lp) <+ transition(lp_target, td, tr, tf);
        V(lm) <+ transition(lm_target, td, tr, tf);
    end
endmodule
