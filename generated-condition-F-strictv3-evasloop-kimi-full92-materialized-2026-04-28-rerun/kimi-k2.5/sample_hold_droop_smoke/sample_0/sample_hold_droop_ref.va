`include "constants.vams"
`include "disciplines.vams"

module sample_hold_droop_ref (vdd, vss, clk, vin, vout);
    input vdd;
    input vss;
    input clk;
    input vin;
    output vout;
    electrical vdd, vss, clk, vin, vout;

    parameter real vth = 0.45;
    parameter real tau = 120n;
    parameter real dt = 0.5n;
    parameter real trf = 40p;

    real vheld;
    real vtarget;
    integer holding;

    analog begin
        @(initial_step) begin
            vheld = 0.0;
            vtarget = 0.0;
            holding = 0;
        end

        @(cross(V(clk) - vth, +1)) begin
            vheld = V(vin);
            vtarget = vheld;
            holding = 1;
        end

        @(timer(0, dt)) begin
            if (holding == 1) begin
                vtarget = vtarget - (vtarget - V(vss)) * dt / tau;
                if (vtarget < V(vss))
                    vtarget = V(vss);
            end
        end

        if (vtarget > V(vdd))
            vtarget = V(vdd);
        else if (vtarget < V(vss))
            vtarget = V(vss);

        V(vout) <+ transition(vtarget, 0, trf, trf);
    end
endmodule
