`include "constants.vams"
`include "disciplines.vams"

module not_gate (VDD, VSS, A, Y);
    input VDD;
    input VSS;
    input A;
    output Y;
    electrical VDD, VSS, A, Y;

    parameter real vth_ratio = 0.5 from (0:1);
    parameter real tdel = 1e-9 from (0:inf);
    parameter real tr = 1e-9 from (0:inf);
    parameter real tf = 1e-9 from (0:inf);

    real vdd_level;
    real vth;
    integer y_val;

    analog begin
        @(initial_step) begin
            vdd_level = V(VDD) - V(VSS);
            vth = vdd_level * vth_ratio;
            y_val = 0;
        end

        if (V(A) - V(VSS) > vth)
            y_val = 0;
        else
            y_val = 1;

        V(Y) <+ V(VSS) + transition(y_val * vdd_level, tdel, tr, tf);
    end
endmodule
