simulator lang=spectre
global 0

ahdl_include "cppll_timer_ref.va"

VDD (VDD 0) vsource dc=1.8
VSS (VSS 0) vsource dc=0.0

Vref (ref_clk 0) vsource type=pulse val0=0 val1=1.8 period=20n rise=0.1n fall=0.1n width=10n
Vref_step (ref_clk 0) vsource type=pwl wave=[0 0 2u 0 2.001u 0 2.002u 1.8 2.012u 1.8 2.013u 0 2.023u 0 2.024u 1.8 2.034u 1.8 2.035u 0 2.045u 0 2.046u 1.8 2.056u 1.8 2.057u 0 2.067u 0 2.068u 1.8 2.078u 1.8 2.079u 0 2.089u 0 2.09u 1.8 2.1u 1.8 2.101u 0 2.111u 0 2.112u 1.8 2.122u 1.8 2.123u 0 2.133u 0 2.134u 1.8 2.144u 1.8 2.145u 0 2.155u 0 2.156u 1.8 2.166u 1.8 2.167u 0 2.177u 0 2.178u 1.8 2.188u 1.8 2.189u 0 2.199u 0 2.2u 1.8 2.21u 1.8 2.211u 0 2.221u 0 2.222u 1.8 2.232u 1.8 2.233u 0 2.243u 0 2.244u 1.8 2.254u 1.8 2.255u 0 2.265u 0 2.266u 1.8 2.276u 1.8 2.277u 0 2.287u 0 2.288u 1.8 2.298u 1.8 2.299u 0 2.309u 0 2.31u 1.8 2.32u 1.8 2.321u 0 2.331u 0 2.332u 1.8 2.342u 1.8 2.343u 0 2.353u 0 2.354u 1.8 2.364u 1.8 2.365u 0 2.375u 0 2.376u 1.8 2.386u 1.8 2.387u 0 2.397u 0 2.398u 1.8 2.408u 1.8 2.409u 0 2.419u 0 2.42u 1.8 2.43u 1.8 2.431u 0 2.441u 0 2.442u 1.8 2.452u 1.8 2.453u 0 2.463u 0 2.464u 1.8 2.474u 1.8 2.475u 0 2.485u 0 2.486u 1.8 2.496u 1.8 2.497u 0 2.507u 0 2.508u 1.8 2.518u 1.8 2.519u 0 2.529u 0 2.53u 1.8 2.54u 1.8 2.541u 0 2.551u 0 2.552u 1.8 2.562u 1.8 2.563u 0 2.573u 0 2.574u 1.8 2.584u 1.8 2.585u 0 2.595u 0 2.596u 1.8 2.606u 1.8 2.607u 0 2.617u 0 2.618u 1.8 2.628u 1.8 2.629u 0 2.639u 0 2.64u 1.8 2.65u 1.8 2.651u 0 2.661u 0 2.662u 1.8 2.672u 1.8 2.673u 0 2.683u 0 2.684u 1.8 2.694u 1.8 2.695u 0 2.705u 0 2.706u 1.8 2.716u 1.8 2.717u 0 2.727u 0 2.728u 1.8 2.738u 1.8 2.739u 0 2.749u 0 2.75u 1.8 2.76u 1.8 2.761u 0 2.771u 0 2.772u 1.8 2.782u 1.8 2.783u 0 2.793u 0 2.794u 1.8 2.804u 1.8 2.805u 0 2.815u 0 2.816u 1.8 2.826u 1.8 2.827u 0 2.837u 0 2.838u 1.8 2.848u 1.8 2.849u 0 2.859u 0 2.86u 1.8 2.87u 1.8 2.871u 0 2.881u 0 2.882u 1.8 2.892u 1.8 2.893u 0 2.903u 0 2.904u 1.8 2.914u 1.8 2.915u 0 2.925u 0 2.926u 1.8 2.936u 1.8 2.937u 0 2.947u 0 2.948u 1.8 2.958u 1.8 2.959u 0 2.969u 0 2.97u 1.8 2.98u 1.8 2.981u 0 2.991u 0 2.992u 1.8 3.002u 1.8 3.003u 0 3.013u 0 3.014u 1.8 3.024u 1.8 3.025u 0 3.035u 0 3.036u 1.8 3.046u 1.8 3.047u 0 3.057u 0 3.058u 1.8 3.068u 1.8 3.069u 0 3.079u 0 3.08u 1.8 3.09u 1.8 3.091u 0 3.101u 0 3.102u 1.8 3.112u 1.8 3.113u 0 3.123u 0 3.124u 1.8 3.134u 1.8 3.135u 0 3.145u 0 3.146u 1.8 3.156u 1.8 3.157u 0 3.167u 0 3.168u 1.8 3.178u 1.8 3.179u 0 3.189u 0 3.19u 1.8 3.2u 1.8 3.201u 0 3.211u 0 3.212u 1.8 3.222u 1.8 3.223u 0 3.233u 0 3.234u 1.8 3.244u 1.8 3.245u 0 3.255u 0 3.256u 1.8 3.266u 1.8 3.267u 0 3.277u 0 3.278u 1.8 3.288u 1.8 3.289u 0 3.299u 0 3.3u 1.8 3.31u 1.8 3.311u 0 3.321u 0 3.322u 1.8 3.332u 1.8 3.333u 0 3.343u 0 3.344u 1.8 3.354u 1.8 3.355u 0 3.365u 0 3.366u 1.8 3.376u 1.8 3.377u 0 3.387u 0 3.388u 1.8 3.398u 1.8 3.399u 0 3.409u 0 3.41u 1.8 3.42u 1.8 3.421u 0 3.431u 0 3.432u 1.8 3.442u 1.8 3.443u 0 3.453u 0 3.454u 1.8 3.464u 1.8 3.465u 0 3.475u 0 3.476u 1.8 3.486u 1.8 3.487u 0 3.497u 0 3.498u 1.8 3.508u 1.8 3.509u 0 3.519u 0 3.52u 1.8 3.53u 1.8 3.531u 0 3.541u 0 3.542u 1.8 3.552u 1.8 3.553u 0 3.563u 0 3.564u 1.8 3.574u 1.8 3.575u 0 3.585u 0 3.586u 1.8 3.596u 1.8 3.597u 0 3.607u 0 3.608u 1.8 3.618u 1.8 3.619u 0 3.629u 0 3.63u 1.8 3.64u 1.8 3.641u 0 3.651u 0 3.652u 1.8 3.662u 1.8 3.663u 0 3.673u 0 3.674u 1.8 3.684u 1.8 3.685u 0 3.695u 0 3.696u 1.8 3.706u 1.8 3.707u 0 3.717u 0 3.718u 1.8 3.728u 1.8 3.729u 0 3.739u 0 3.74u 1.8 3.75u 1.8 3.751u 0 3.761u 0 3.762u 1.8 3.772u 1.8 3.773u 0 3.783u 0 3.784u 1.8 3.794u 1.8 3.795u 0 3.805u 0 3.806u 1.8 3.816u 1.8 3.817u 0 3.827u 0 3.828u 1.8 3.838u 1.8 3.839u 0 3.849u 0 3.85u 1.8 3.86u 1.8 3.861u 0 3.871u 0 3.872u 1.8 3.882u 1.8 3.883u 0 3.893u 0 3.894u 1.8 3.904u 1.8 3.905u 0 3.915u 0 3.916u 1.8 3.926u 1.8 3.927u 0 3.937u 0 3.938u 1.8 3.948u 1.8 3.949u 0 3.959u 0 3.96u 1.8 3.97u 1.8 3.971u 0 3.981u 0 3.982u 1.8 3.992u 1.8 3.993u 0 4.003u 0 4.004u 1.8 4.014u 1.8 4.015u 0 4.025u 0 4.026u 1.8 4.036u 1.8 4.037u 0 4.047u 0 4.048u 1.8 4.058u 1.8 4.059u 0 4.069u 0 4.07u 1.8 4.08u 1.8 4.081u 0 4.091u 0 4.092u 1.8 4.102u 1.8 4.103u 0 4.113u 0 4.114u 1.8 4.124u 1.8 4.125u 0 4.135u 0 4.136u 1.8 4.146u 1.8 4.147u 0 4.157u 0 4.158u 1.8 4.168u 1.8 4.169u 0 4.179u 0 4.18u 1.8 4.19u 1.8 4.191u 0 4.201u 0 4.202u 1.8 4.212u 1.8 4.213u 0 4.223u 0 4.224u 1.8 4.234u 1.8 4.235u 0 4.245u 0 4.246u 1.8 4.256u 1.8 4.257u 0 4.267u 0 4.268u 1.8 4.278u 1.8 4.279u 0 4.289u 0 4.29u 1.8 4.3u 1.8 4.301u 0 4.311u 0 4.312u 1.8 4.322u 1.8 4.323u 0 4.333u 0 4.334u 1.8 4.344u 1.8 4.345u 0 4.355u 0 4.356u 1.8 4.366u 1.8 4.367u 0 4.377u 0 4.378u 1.8 4.388u 1.8 4.389u 0 4.399u 0 4.4u 1.8 4.41u 1.8 4.411u 0 4.421u 0 4.422u 1.8 4.432u 1.8 4.433u 0 4.443u 0 4.444u 1.8 4.454u 1.8 4.455u 0 4.465u 0 4.466u 1.8 4.476u 1.8 4.477u 0 4.487u 0 4.488u 1.8 4.498u 1.8 4.499u 0 4.509u 0 4.51u 1.8 4.52u 1.8 4.521u 0 4.531u 0 4.532u 1.8 4.542u 1.8 4.543u 0 4.553u 0 4.554u 1.8 4.564u 1.8 4.565u 0 4.575u 0 4.576u 1.8 4.586u 1.8 4.587u 0 4.597u 0 4.598u 1.8 4.608u 1.8 4.609u 0 4.619u 0 4.62u 1.8 4.63u 1.8 4.631u 0 4.641u 0 4.642u 1.8 4.652u 1.8 4.653u 0 4.663u 0 4.664u 1.8 4.674u 1.8 4.675u 0 4.685u 0 4.686u 1.8 4.696u 1.8 4.697u 0 4.707u 0 4.708u 1.8 4.718u 1.8 4.719u 0 4.729u 0 4.73u 1.8 4.74u 1.8 4.741u 0 4.751u 0 4.752u 1.8 4.762u 1.8 4.763u 0 4.773u 0 4.774u 1.8 4.784u 1.8 4.785u 0 4.795u 0 4.796u 1.8 4.806u 1.8 4.807u 0 4.817u 0 4.818u 1.8 4.828u 1.8 4.829u 0 4.839u 0 4.84u 1.8 4.85u 1.8 4.851u 0 4.861u 0 4.862u 1.8 4.872u 1.8 4.873u 0 4.883u 0 4.884u 1.8 4.894u 1.8 4.895u 0 4.905u 0 4.906u 1.8 4.916u 1.8 4.917u 0 4.927u 0 4.928u 1.8 4.938u 1.8 4.939u 0 4.949u 0 4.95u 1.8 4.96u 1.8 4.961u 0 4.971u 0 4.972u 1.8 4.982u 1.8 4.983u 0 4.993u 0 4.994u 1.8 5.004u 1.8 5.005u 0 5.015u 0 5.016u 1.8 5.026u 1.8 5.027u 0 5.037u 0 5.038u 1.8 5.048u 1.8 5.049u 0 5.059u 0 5.06u 1.8 5.07u 1.8 5.071u 0 5.081u 0 5.082u 1.8 5.092u 1.8 5.093u 0 5.103u 0 5.104u 1.8 5.114u 1.8 5.115u 0 5.125u 0 5.126u 1.8 5.136u 1.8 5.137u 0 5.147u 0 5.148u 1.8 5.158u 1.8 5.159u 0 5.169u 0 5.17u 1.8 5.18u 1.8 5.181u 0 5.191u 0 5.192u 1.8 5.202u 1.8 5.203u 0 5.213u 0 5.214u 1.8 5.224u 1.8 5.225u 0 5.235u 0 5.236u 1.8 5.246u 1.8 5.247u 0 5.257u 0 5.258u 1.8 5.268u 1.8 5.269u 0 5.279u 0 5.28u 1.8 5.29u 1.8 5.291u 0 5.301u 0 5.302u 1.8 5.312u 1.8 5.313u 0 5.323u 0 5.324u 1.8 5.334u 1.8 5.335u 0 5.345u 0 5.346u 1.8 5.356u 1.8 5.357u 0 5.367u 0 5.368u 1.8 5.378u 1.8 5.379u 0 5.389u 0 5.39u 1.8 5.4u 1.8 5.401u 0 5.411u 0 5.412u 1.8 5.422u 1.8 5.423u 0 5.433u 0 5.434u 1.8 5.444u 1.8 5.445u 0 5.455u 0 5.456u 1.8 5.466u 1.8 5.467u 0 5.477u 0 5.478u 1.8 5.488u 1.8 5.489u 0 5.499u 0 5.5u 1.8 5.51u 1.8 5.511u 0 5.521u 0 5.522u 1.8 5.532u 1.8 5.533u 0 5.543u 0 5.544u 1.8 5.554u 1.8 5.555u 0 5.565u 0 5.566u 1.8 5.576u 1.8 5.577u 0 5.587u 0 5.588u 1.8 5.598u 1.8 5.599u 0 5.609u 0 5.61u 1.8 5.62u 1.8 5.621u 0 5.631u 0 5.632u 1.8 5.642u 1.8 5.643u 0 5.653u 0 5.654u 1.8 5.664u 1.8 5.665u 0 5.675u 0 5.676u 1.8 5.686u 1.8 5.687u 0 5.697u 0 5.698u 1.8 5.708u 1.8 5.709u 0 5.719u 0 5.72u 1.8 5.73u 1.8 5.731u 0 5.741u 0 5.742u 1.8 5.752u 1.8 5.753u 0 5.763u 0 5.764u 1.8 5.774u 1.8 5.775u 0 5.785u 0 5.786u 1.8 5.796u 1.8 5.797u 0 5.807u 0 5.808u 1.8 5.818u 1.8 5.819u 0 5.829u 0 5.83u 1.8 5.84u 1.8 5.841u 0 5.851u 0 5.852u 1.8 5.862u 1.8 5.863u 0 5.873u 0 5.874u 1.8 5.884u 1.8 5.885u 0 5.895u 0 5.896u 1.8 5.906u 1.8 5.907u 0 5.917u 0 5.918u 1.8 5.928u 1.8 5.929u 0 5.939u 0 5.94u 1.8 5.95u 1.8 5.951u 0 5.961u 0 5.962u 1.8 5.972u 1.8 5.973u 0 5.983u 0 5.984u 1.8 5.994u 1.8 5.995u 0 6.005u 0]

XDUT (VDD VSS ref_clk fb_clk dco_clk vctrl_mon lock) cppll_timer_ref

save ref_clk fb_clk lock vctrl_mon

tran tran stop=6u maxstep=5n errpreset=conservative
