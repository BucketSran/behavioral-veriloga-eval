`include "constants.vams"
`include "disciplines.vams"

module sar_adc_weighted_8b (vin, clks, rst_n, dout_7, dout_6, dout_5, dout_4, dout_3, dout_2, dout_1, dout_0);
    input vin;
    input clks;
    input rst_n;
    output dout_7;
    output dout_6;
    output dout_5;
    output dout_4;
    output dout_3;
    output dout_2;
    output dout_1;
    output dout_0;
    electrical vin;
    electrical clks;
    electrical rst_n;
    electrical dout_7, dout_6, dout_5, dout_4, dout_3, dout_2, dout_1, dout_0;

    parameter real vdd = 0.9 from (0:inf);
    parameter real vth = 0.45 from (0:inf);
    parameter real tdel = 0 from [0:inf);
    parameter real tr = 1n from (0:inf);
    parameter real tf = 1n from (0:inf);

    integer code;
    integer bit7, bit6, bit5, bit4, bit3, bit2, bit1, bit0;
    real vin_val;
    integer rst_active;

    analog begin
        @(initial_step) begin
            code = 0;
            bit7 = 0; bit6 = 0; bit5 = 0; bit4 = 0;
            bit3 = 0; bit2 = 0; bit1 = 0; bit0 = 0;
            rst_active = 1;
        end

        @(cross(V(rst_n) - vth, -1)) begin
            rst_active = 0;
        end

        @(cross(V(rst_n) - vth, +1)) begin
            rst_active = 1;
            code = 0;
            bit7 = 0; bit6 = 0; bit5 = 0; bit4 = 0;
            bit3 = 0; bit2 = 0; bit1 = 0; bit0 = 0;
        end

        @(cross(V(clks) - vth, +1)) begin
            if (!rst_active) begin
                vin_val = V(vin);
                if (vin_val < 0) begin
                    code = 0;
                end else if (vin_val > vdd) begin
                    code = 255;
                end else begin
                    code = $floor(vin_val / vdd * 255.0);
                    if (code < 0) code = 0;
                    if (code > 255) code = 255;
                end
                bit7 = (code >> 7) & 1;
                bit6 = (code >> 6) & 1;
                bit5 = (code >> 5) & 1;
                bit4 = (code >> 4) & 1;
                bit3 = (code >> 3) & 1;
                bit2 = (code >> 2) & 1;
                bit1 = (code >> 1) & 1;
                bit0 = code & 1;
            end
        end

        V(dout_7) <+ transition(bit7 * vdd, tdel, tr, tf);
        V(dout_6) <+ transition(bit6 * vdd, tdel, tr, tf);
        V(dout_5) <+ transition(bit5 * vdd, tdel, tr, tf);
        V(dout_4) <+ transition(bit4 * vdd, tdel, tr, tf);
        V(dout_3) <+ transition(bit3 * vdd, tdel, tr, tf);
        V(dout_2) <+ transition(bit2 * vdd, tdel, tr, tf);
        V(dout_1) <+ transition(bit1 * vdd, tdel, tr, tf);
        V(dout_0) <+ transition(bit0 * vdd, tdel, tr, tf);
    end
endmodule
