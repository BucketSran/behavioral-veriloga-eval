simulator lang=spectre
global 0

ahdl_include "mux_4to1.va"

// Power supplies
Vdd (vdd 0) vsource dc=0.9
Vss (vss 0) vsource dc=0

// Data inputs - distinctive voltages
Vd0 (d0 0) vsource dc=0.1
Vd1 (d1 0) vsource dc=0.3
Vd2 (d2 0) vsource dc=0.6
Vd3 (d3 0) vsource dc=0.8

// Selection inputs - walk through 00, 01, 10, 11
// sel0: 0->1 at 100ns, 0->1 at 300ns (period 200ns, 50% duty for bit0)
// sel1: 0->1 at 200ns (period 400ns, 50% duty for bit1)
Vsel0 (sel0 0) vsource type=pulse val0=0 val1=0.9 period=200n rise=1n fall=1n width=99n delay=100n
Vsel1 (sel1 0) vsource type=pulse val0=0 val1=0.9 period=400n rise=1n fall=1n width=199n delay=200n

// DUT instance
XDUT (vdd vss d3 d2 d1 d0 sel1 sel0 y) mux_4to1

// Save signals
save d0 d1 d2 d3 sel1 sel0 y

// Transient analysis
tran tran stop=420n maxstep=1n errpreset=conservative
