`include "constants.vams"
`include "disciplines.vams"

module or_gate (a, b, y);
    electrical a, b, y;
    parameter real vdd = 1.8 from (0:inf);
    parameter real tedge = 10p from (0:inf);

    real vout;
    real vth;

    analog begin
        vth = vdd / 2.0;

        // Determine output based on OR logic
        if (V(a) > vth || V(b) > vth) begin
            vout = vdd;
        end else begin
            vout = 0.0;
        end

        // Drive output with transition
        V(y) <+ transition(vout, 0, tedge);
    end
endmodule
