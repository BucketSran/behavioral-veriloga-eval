// tb_pfd_updn.scs - Spectre testbench for pfd_updn

ahdl_include "pfd_updn.va"

// Supply voltages
VDD (vdd 0) vsource dc=0.9
VSS (vss 0) vsource dc=0

// Reference clock: 100MHz, starts at 0 phase
Vref (ref 0) vsource type=pulse val0=0 val1=0.9 period=10n rise=10p fall=10p width=5n

// Divided clock: 100MHz with small phase offset (~5ps)
// This creates small phase error to test deadzone behavior
Vdiv (div 0) vsource type=pulse val0=0 val1=0.9 period=10n rise=10p fall=10p width=5n delay=5.005n

// DUT instance
pfd (vdd vss ref div up dn) pfd_updn

// Save statements for required signals
save ref div up dn

// Transient analysis
tran tran stop=300n maxstep=5p errpreset=conservative
