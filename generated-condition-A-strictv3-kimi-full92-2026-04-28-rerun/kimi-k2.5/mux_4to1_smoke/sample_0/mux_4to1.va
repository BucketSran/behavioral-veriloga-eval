`include "constants.vams"
`include "disciplines.vams"

module mux_4to1 (vdd, vss, d3, d2, d1, d0, sel1, sel0, y);
    electrical vdd, vss, d3, d2, d1, d0, sel1, sel0, y;

    parameter real vth = 0.45;
    parameter real tedge = 100p;

    integer sel;
    real selected;

    analog begin
        // Decode select inputs
        if (V(sel1) > vth)
            sel = 2;
        else
            sel = 0;

        if (V(sel0) > vth)
            sel = sel + 1;

        // Select the appropriate input
        case (sel)
            0: selected = V(d0);
            1: selected = V(d1);
            2: selected = V(d2);
            3: selected = V(d3);
            default: selected = V(d0);
        endcase

        // Output with transition
        V(y) <+ transition(selected, 0, tedge);
    end
endmodule
