`include "constants.vams"
`include "disciplines.vams"

module multitone (OUT);
    output OUT;
    electrical OUT;

    // Parameters for up to 8 tones
    parameter real freq[0:7] = '{1e6, 0, 0, 0, 0, 0, 0, 0};
    parameter real amp[0:7] = '{1.0, 0, 0, 0, 0, 0, 0, 0};

    // Internal variables
    real max_freq;
    real period;
    real t;
    real sum;
    integer i;

    analog begin
        // Find maximum frequency for bound_step
        @(initial_step) begin
            max_freq = 0.0;
            for (i = 0; i < 8; i = i + 1) begin
                if (freq[i] > max_freq) begin
                    max_freq = freq[i];
                end
            end
        end

        // Apply bound_step based on highest frequency
        // Use 10 points per period of highest frequency
        if (max_freq > 0) begin
            period = 1.0 / max_freq;
            $bound_step(period / 10.0);
        end

        // Calculate sum of sinusoids
        t = $abstime;
        sum = 0.0;
        for (i = 0; i < 8; i = i + 1) begin
            if (freq[i] > 0) begin
                sum = sum + amp[i] * sin(2.0 * `M_PI * freq[i] * t);
            end
        end

        // Output the multitone signal
        V(OUT) <+ sum;
    end
endmodule
