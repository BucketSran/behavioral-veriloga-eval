// Spectre testbench for bbpd_data_edge_alignment_ref

// Include the Verilog-A model
ahdl_include "bbpd_data_edge_alignment_ref.va"

// Supply voltages
vsource vdd (vdd 0) vdc=1.0
vsource vss (vss 0) vdc=0.0

// Clock source - 500MHz clock (2ns period)
vsource vclk (clk 0) vdc=0.0 vpulse=(0 1.0 0 0.1n 0.1n 0.9n 2.0n)

// Data source - pattern with intentional phase variations
// Create data edges at various alignments relative to clock
// Using vpulse with different delays to create phase sweep

// Data pattern: start aligned, then lead, then lag, then lead, etc.
// Period: 4ns (half clock rate for NRZ-like data)
// Phase modulation: 0, +0.3n (lead), -0.3n (lag), +0.5n, -0.5n, etc.

// Create data with phase modulation using piecewise linear
vsource vdata (data 0) vdc=0.0 \
    vpwl=[ \
        0n      0.0 \
        0.5n    0.0 \
        0.6n    1.0 \
        2.0n    1.0 \
        2.1n    0.0 \
        3.5n    0.0 \
        3.6n    1.0 \
        5.0n    1.0 \
        5.1n    0.0 \
        6.5n    0.0 \
        6.6n    1.0 \
        8.0n    1.0 \
        8.1n    0.0 \
        9.5n    0.0 \
        9.6n    1.0 \
        11.0n   1.0 \
        11.1n   0.0 \
        12.5n   0.0 \
        12.6n   1.0 \
        14.0n   1.0 \
        14.1n   0.0 \
        15.5n   0.0 \
        15.6n   1.0 \
        17.0n   1.0 \
        17.1n   0.0 \
        18.5n   0.0 \
        18.6n   1.0 \
        20.0n   1.0 \
        20.1n   0.0 \
        21.5n   0.0 \
        21.6n   1.0 \
        23.0n   1.0 \
        23.1n   0.0 \
        24.5n   0.0 \
        24.6n   1.0 \
        26.0n   1.0 \
        26.1n   0.0 \
        27.5n   0.0 \
        27.6n   1.0 \
        29.0n   1.0 \
        29.1n   0.0 \
        30.5n   0.0 \
        30.6n   1.0 \
        32.0n   1.0 \
        32.1n   0.0 \
        33.5n   0.0 \
        33.6n   1.0 \
        35.0n   1.0 \
        35.1n   0.0 \
        36.5n   0.0 \
        36.6n   1.0 \
        38.0n   1.0 \
        38.1n   0.0 \
        39.5n   0.0 \
        39.6n   1.0 \
        41.0n   1.0 \
        41.1n   0.0 \
        42.5n   0.0 \
        42.6n   1.0 \
        44.0n   1.0 \
        44.1n   0.0 \
        45.5n   0.0 \
        45.6n   1.0 \
        47.0n   1.0 \
        47.1n   0.0 \
        48.5n   0.0 \
        48.6n   1.0 \
        50.0n   1.0 \
        50.1n   0.0 \
        51.5n   0.0 \
        51.6n   1.0 \
        53.0n   1.0 \
        53.1n   0.0 \
        54.5n   0.0 \
        54.6n   1.0 \
        56.0n   1.0 \
        56.1n   0.0 \
        57.5n   0.0 \
        57.6n   1.0 \
        59.0n   1.0 \
        59.1n   0.0 \
        60.5n   0.0 \
        60.6n   1.0 \
        62.0n   1.0 \
        62.1n   0.0 \
        63.5n   0.0 \
        63.6n   1.0 \
        65.0n   1.0 \
        65.1n   0.0 \
        66.5n   0.0 \
        66.6n   1.0 \
        68.0n   1.0 \
        68.1n   0.0 \
        69.5n   0.0 \
        69.6n   1.0 \
        71.0n   1.0 \
        71.1n   0.0 \
        72.5n   0.0 \
        72.6n   1.0 \
        74.0n   1.0 \
        74.1n   0.0 \
        75.5n   0.0 \
        75.6n   1.0 \
        77.0n   1.0 \
        77.1n   0.0 \
        78.5n   0.0 \
        78.6n   1.0 \
        80.0n   1.0 \
        80.1n   0.0 \
        81.5n   0.0 \
        81.6n   1.0 \
        83.0n   1.0 \
        83.1n   0.0 \
        84.5n   0.0 \
        84.6n   1.0 \
        86.0n   1.0 \
        86.1n   0.0 \
        87.5n   0.0 \
        87.6n   1.0 \
        89.0n   1.0 \
        89.1n   0.0 \
        90.5n   0.0 \
        90.6n   1.0 \
        92.0n   1.0 \
        92.1n   0.0 \
        93.5n   0.0 \
        93.6n   1.0 \
        95.0n   1.0 \
        95.1n   0.0 \
        96.5n   0.0 \
        96.6n   1.0 \
        98.0n   1.0 \
        98.1n   0.0 \
        99.5n   0.0 \
        99.6n   1.0 \
        101.0n  1.0 \
        101.1n  0.0 \
        102.5n  0.0 \
        102.6n  1.0 \
        104.0n  1.0 \
        104.1n  0.0 \
        105.5n  0.0 \
        105.6n  1.0 \
        107.0n  1.0 \
        107.1n  0.0 \
        108.5n  0.0 \
        108.6n  1.0 \
        110.0n  1.0 \
        110.1n  0.0 \
        111.5n  0.0 \
        111.6n  1.0 \
        113.0n  1.0 \
        113.1n  0.0 \
        114.5n  0.0 \
        114.6n  1.0 \
        116.0n  1.0 \
        116.1n  0.0 \
        117.5n  0.0 \
        117.6n  1.0 \
        119.0n  1.0 \
        119.1n  0.0 \
        120.5n  0.0 \
        120.6n  1.0 \
        122.0n  1.0 \
        122.1n  0.0 \
        123.5n  0.0 \
        123.6n  1.0 \
        125.0n  1.0 \
        125.1n  0.0 \
        126.5n  0.0 \
        126.6n  1.0 \
        128.0n  1.0 \
        128.1n  0.0 \
        129.5n  0.0 \
        129.6n  1.0 \
        131.0n  1.0 \
        131.1n  0.0 \
        132.5n  0.0 \
        132.6n  1.0 \
        134.0n  1.0 \
        134.1n  0.0 \
        135.5n  0.0 \
        135.6n  1.0 \
        137.0n  1.0 \
        137.1n  0.0 \
        138.5n  0.0 \
        138.6n  1.0 \
        140.0n  1.0 \
        140.1n  0.0 \
        141.5n  0.0 \
        141.6n  1.0 \
        143.0n  1.0 \
        143.1n  0.0 \
        144.5n  0.0 \
        144.6n  1.0 \
        146.0n  1.0 \
        146.1n  0.0 \
        147.5n  0.0 \
        147.6n  1.0 \
        149.0n  1.0 \
        149.1n  0.0 \
        150.5n  0.0 \
        150.6n  1.0 \
        152.0n  1.0 \
        152.1n  0.0 \
        153.5n  0.0 \
        153.6n  1.0 \
        155.0n  1.0 \
        155.1n  0.0 \
        156.5n  0.0 \
        156.6n  1.0 \
        158.0n  1.0 \
        158.1n  0.0 \
        159.5n  0.0 \
        159.6n  1.0 \
        161.0n  1.0 \
        161.1n  0.0 \
        162.5n  0.0 \
        162.6n  1.0 \
        164.0n  1.0 \
        164.1n  0.0 \
        165.5n  0.0 \
        165.6n  1.0 \
        167.0n  1.0 \
        167.1n  0.0 \
        168.5n  0.0 \
        168.6n  1.0 \
        170.0n  1.0 \
    ]

// DUT instance
bbpd_data_edge_alignment_ref dut (
    .vdd            vdd
    .vss            vss
    .clk            clk
    .data           data
    .up             up
    .dn             dn
    .retimed_data   retimed_data
)

// Transient analysis
tran tran stop=170n maxstep=0.1n

// Save statements for required signals
save clk
save data
save up
save dn
