`include "constants.vams"
`include "disciplines.vams"

module transition_branch_target_ref (VDD, VSS, mode, clk, out);
    inout electrical VDD;
    inout electrical VSS;
    input electrical mode;
    input electrical clk;
    output electrical out;

    parameter real vth = 0.6 from (0:inf);
    parameter real tr = 1n from (0:inf);
    parameter real tf = 1n from (0:inf);
    parameter real td = 0 from [0:inf);

    integer target_q;
    real vdd_val;
    real vss_val;

    analog begin
        @(initial_step) begin
            target_q = 0;
        end

        // Sample VDD/VSS for output levels
        vdd_val = V(VDD);
        vss_val = V(VSS);

        // Detect rising edge of clk
        @(cross(V(clk) - vth, 1)) begin
            if (V(mode) > vth) begin
                target_q = 1;
            end else begin
                target_q = 0;
            end
        end

        // Drive output with transition
        V(out) <+ transition(target_q ? vdd_val : vss_val, td, tr, tf);
    end
endmodule
