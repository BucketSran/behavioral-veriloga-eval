// Spectre testbench for dac_binary_clk_4b
// EVAS-compatible, minimal testbench

// Include the Verilog-A module
ahdl_include "dac_binary_clk_4b.va"

// Parameters
parameters vref=0.9
parameters period=40n
parameters vlogic=0.9
parameters vth=0.45

// Top-level testbench
simulator lang=spectre

// DUT instance
I0 (din3 din2 din1 din0 rdy aout) dac_binary_clk_4b

// Stimulus sources
// Clock: rdy (40ns period, 50% duty cycle)
Vrdy (rdy 0) vsource type=pulse val0=0 val1=vlogic period=period rise=100p fall=100p width=20n

// Digital input stimulus - sweep all 16 codes
// Code 0: 0000 (0ns to 40ns)
Vdin0_0 (din0 0) vsource type=pulse val0=0 val1=0 delay=0n period=640n rise=100p fall=100p width=640n
Vdin1_0 (din1 0) vsource type=pulse val0=0 val1=0 delay=0n period=640n rise=100p fall=100p width=640n
Vdin2_0 (din2 0) vsource type=pulse val0=0 val1=0 delay=0n period=640n rise=100p fall=100p width=640n
Vdin3_0 (din3 0) vsource type=pulse val0=0 val1=0 delay=0n period=640n rise=100p fall=100p width=640n

// Code 1: 0001 (40ns to 80ns) - din0 high
Vdin0_1 (din0 0) vsource type=pulse val0=0 val1=vlogic delay=40n period=640n rise=100p fall=100p width=40n
// Code 2: 0010 (80ns to 120ns) - din1 high
Vdin1_1 (din1 0) vsource type=pulse val0=0 val1=vlogic delay=80n period=640n rise=100p fall=100p width=40n
// Code 3: 0011 (120ns to 160ns) - din0, din1 high
Vdin0_2 (din0 0) vsource type=pulse val0=0 val1=vlogic delay=120n period=640n rise=100p fall=100p width=40n
// Code 4: 0100 (160ns to 200ns) - din2 high
Vdin2_1 (din2 0) vsource type=pulse val0=0 val1=vlogic delay=160n period=640n rise=100p fall=100p width=40n
// Code 5: 0101 (200ns to 240ns) - din0, din2 high
Vdin0_3 (din0 0) vsource type=pulse val0=0 val1=vlogic delay=200n period=640n rise=100p fall=100p width=40n
// Code 6: 0110 (240ns to 280ns) - din1, din2 high
Vdin1_2 (din1 0) vsource type=pulse val0=0 val1=vlogic delay=240n period=640n rise=100p fall=100p width=40n
// Code 7: 0111 (280ns to 320ns) - din0, din1, din2 high
Vdin0_4 (din0 0) vsource type=pulse val0=0 val1=vlogic delay=280n period=640n rise=100p fall=100p width=40n
// Code 8: 1000 (320ns to 360ns) - din3 high
Vdin3_1 (din3 0) vsource type=pulse val0=0 val1=vlogic delay=320n period=640n rise=100p fall=100p width=40n
// Code 9: 1001 (360ns to 400ns) - din0, din3 high
Vdin0_5 (din0 0) vsource type=pulse val0=0 val1=vlogic delay=360n period=640n rise=100p fall=100p width=40n
// Code 10: 1010 (400ns to 440ns) - din1, din3 high
Vdin1_3 (din1 0) vsource type=pulse val0=0 val1=vlogic delay=400n period=640n rise=100p fall=100p width=40n
// Code 11: 1011 (440ns to 480ns) - din0, din1, din3 high
Vdin0_6 (din0 0) vsource type=pulse val0=0 val1=vlogic delay=440n period=640n rise=100p fall=100p width=40n
// Code 12: 1100 (480ns to 520ns) - din2, din3 high
Vdin2_2 (din2 0) vsource type=pulse val0=0 val1=vlogic delay=480n period=640n rise=100p fall=100p width=40n
// Code 13: 1101 (520ns to 560ns) - din0, din2, din3 high
Vdin0_7 (din0 0) vsource type=pulse val0=0 val1=vlogic delay=520n period=640n rise=100p fall=100p width=40n
// Code 14: 1110 (560ns to 600ns) - din1, din2, din3 high
Vdin1_4 (din1 0) vsource type=pulse val0=0 val1=vlogic delay=560n period=640n rise=100p fall=100p width=40n
// Code 15: 1111 (600ns to 640ns) - all high
Vdin0_8 (din0 0) vsource type=pulse val0=0 val1=vlogic delay=600n period=640n rise=100p fall=100p width=40n

// Alternative simpler approach using PWL for cleaner code sweep
// Remove above pulse sources and use this instead:

// Reset and re-run with PWL approach for cleaner stimulus
alter Vrdy (rdy 0) vsource type=pulse val0=0 val1=vlogic period=period rise=100p fall=100p width=20n

// Use PWL for digital inputs - sweep 0 to 15
Vdin0_pwl (din0 0) vsource type=pwl wave=[0n 0 39n 0 40n 0 79n 0 80n vlogic 119n vlogic 120n 0 159n 0 160n 0 199n 0 200n vlogic 239n vlogic 240n 0 279n 0 280n 0 319n 0 320n 0 359n 0 360n vlogic 399n vlogic 400n 0 439n 0 440n 0 479n 0 480n 0 519n 0 520n vlogic 559n vlogic 560n 0 599n 0 600n 0 639n 0 640n vlogic 660n vlogic]
Vdin1_pwl (din1 0) vsource type=pwl wave=[0n 0 79n 0 80n vlogic 119n vlogic 120n 0 159n 0 160n 0 239n 0 240n vlogic 279n vlogic 280n 0 319n 0 320n 0 399n 0 400n vlogic 439n vlogic 440n 0 479n 0 480n 0 559n 0 560n vlogic 599n vlogic 600n 0 639n 0 640n vlogic 660n vlogic]
Vdin2_pwl (din2 0) vsource type=pwl wave=[0n 0 159n 0 160n vlogic 199n vlogic 200n 0 239n 0 240n 0 279n 0 280n 0 319n 0 320n 0 479n 0 480n vlogic 519n vlogic 520n 0 559n 0 560n 0 599n 0 600n 0 639n 0 640n vlogic 660n vlogic]
Vdin3_pwl (din3 0) vsource type=pwl wave=[0n 0 319n 0 320n vlogic 359n vlogic 360n 0 399n 0 400n 0 439n 0 440n 0 479n 0 480n 0 519n 0 520n 0 559n 0 560n 0 599n 0 600n 0 639n 0 640n vlogic 660n vlogic]

// Analysis
tran tran stop=660n maxstep=200p

// Save statements for required waveforms - plain scalar names
save din3
save din2
save din1
save din0
save aout
save rdy
