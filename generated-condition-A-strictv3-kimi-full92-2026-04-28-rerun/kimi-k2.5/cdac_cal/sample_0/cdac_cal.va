`include "constants.vams"
`include "disciplines.vams"

module cdac_cal (
    VDD,
    VSS,
    CLK,
    D9, D8, D7, D6, D5, D4, D3, D2, D1, D0,
    CAL0, CAL1,
    VDAC_P,
    VDAC_N
);

    // Power rails
    inout electrical VDD;
    inout electrical VSS;

    // Clock
    input electrical CLK;

    // Digital inputs (10-bit binary weighted)
    input electrical D9, D8, D7, D6, D5, D4, D3, D2, D1, D0;

    // Calibration inputs (2 redundant bits)
    input electrical CAL0, CAL1;

    // Differential DAC outputs
    output electrical VDAC_P;
    output electrical VDAC_N;

    // Parameters
    parameter real vdd_nom = 1.8 from (0:inf);
    parameter real vth = 0.9 from (0:vdd_nom);
    parameter real tr = 100p from (0:inf);
    parameter real tf = 100p from (0:inf);
    parameter real td = 0 from [0:inf);

    // Capacitor weight parameters (binary weighted, normalized to total array)
    // Main 10-bit array: 512, 256, 128, 64, 32, 16, 8, 4, 2, 1 (units of C)
    // Total main array: 1023C
    // Calibration capacitors: typically 1C each (redundant LSBs)
    parameter real C_unit = 1e-15 from (0:inf);  // Unit capacitance in Farads

    // Internal variables
    integer state;
    real vdd_val, vss_val;
    real clk_prev;
    real d[0:9];      // Digital input values (0 or 1)
    real cal[0:1];    // Calibration input values
    real code_p, code_n;
    real vout_p, vout_n;
    real vcm;

    // Charge redistribution model
    // For differential CDAC with top-plate sampling:
    // VDAC_P = VCM + (VDD - VSS) * (code_p - code_n) / 2^N_eff
    // VDAC_N = VCM - (VDD - VSS) * (code_p - code_n) / 2^N_eff

    analog begin
        @(initial_step) begin
            state = 0;
            clk_prev = 0;
            vout_p = 0.9;
            vout_n = 0.9;
        end

        // Sample power supply values
        vdd_val = V(VDD);
        vss_val = V(VSS);
        vcm = (vdd_val + vss_val) / 2.0;

        // Sample digital inputs (convert to 0/1 based on threshold)
        d[9] = (V(D9) > vth) ? 1.0 : 0.0;
        d[8] = (V(D8) > vth) ? 1.0 : 0.0;
        d[7] = (V(D7) > vth) ? 1.0 : 0.0;
        d[6] = (V(D6) > vth) ? 1.0 : 0.0;
        d[5] = (V(D5) > vth) ? 1.0 : 0.0;
        d[4] = (V(D4) > vth) ? 1.0 : 0.0;
        d[3] = (V(D3) > vth) ? 1.0 : 0.0;
        d[2] = (V(D2) > vth) ? 1.0 : 0.0;
        d[1] = (V(D1) > vth) ? 1.0 : 0.0;
        d[0] = (V(D0) > vth) ? 1.0 : 0.0;

        // Sample calibration inputs
        cal[0] = (V(CAL0) > vth) ? 1.0 : 0.0;
        cal[1] = (V(CAL1) > vth) ? 1.0 : 0.0;

        // Detect clock edge (rising edge for SAR operation)
        @(cross(V(CLK) - vth, 1)) begin
            state = state + 1;

            // Calculate binary-weighted code for positive side
            // Weights: 512, 256, 128, 64, 32, 16, 8, 4, 2, 1
            code_p = 512.0 * d[9] + 256.0 * d[8] + 128.0 * d[7] + 64.0 * d[6] +
                     32.0 * d[5] + 16.0 * d[4] + 8.0 * d[3] + 4.0 * d[2] +
                     2.0 * d[1] + 1.0 * d[0];

            // Add calibration capacitors (1C each, same weight as LSB)
            code_p = code_p + 1.0 * cal[0] + 1.0 * cal[1];

            // For differential operation, negative side gets complementary code
            // Total capacitance per side: 1024C (main) + 2C (cal) = 1026C
            // For true differential: code_n = 1023 - code_main (inverted)
            // With calibration: we model as code_n being the complement

            // Simplified model: code_n represents the negative side accumulation
            // In a real SAR, the comparator decision determines which side gets the charge
            // Here we model the output voltage based on the digital code

            // Total effective bits: 10 main + 2 cal = 12 levels, but cal are redundant LSBs
            // Effective full scale: 1024 (2^10) + 2 = 1026 levels
            real total_caps = 1026.0;

            // Normalized output: 0 to 1 range, then scaled to supply
            real norm_p = code_p / total_caps;
            real norm_n = (1023.0 - code_p + cal[0] + cal[1]) / total_caps;

            // Differential output: centered around VCM
            // VDAC_P - VDAC_N represents the differential voltage
            vout_p = vss_val + (vdd_val - vss_val) * norm_p;
            vout_n = vss_val + (vdd_val - vss_val) * norm_n;
        end

        // Output with transition for smooth analog behavior
        V(VDAC_P) <+ transition(vout_p, td, tr, tf);
        V(VDAC_N) <+ transition(vout_n, td, tr, tf);
    end

endmodule
