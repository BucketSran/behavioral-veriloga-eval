simulator lang=spectre
global 0

// Supply voltages
VDD (VDD 0) vsource dc=0.9
VSS (VSS 0) vsource dc=0

// Differential input step: 10mV differential step at 10ns
// Common mode at 0.45V (mid-rail)
// vinp steps from 0.445V to 0.455V
// vinn steps from 0.455V to 0.445V
VINP (vinp 0) vsource dc=0.445 type=pulse val0=0.445 val1=0.455 period=200n delay=10n rise=100p fall=100p width=100n
VINN (vinn 0) vsource dc=0.455 type=pulse val0=0.455 val1=0.445 period=200n delay=10n rise=100p fall=100p width=100n

// DUT instance
XDUT (VDD VSS vinp vinn voutp voutn) gain_step_ref

// Transient analysis
tran tran stop=100n maxstep=100p

// Save waveforms
save vinp vinn voutp voutn

// Include DUT Verilog-A
ahdl_include "gain_step_ref.va"
