// Spectre testbench for pfd_updn

ahdl_include "pfd_updn.va"

// Supply voltages
Vvdd (vdd 0) vsource dc=0.9
Vvss (vss 0) vsource dc=0

// Reference clock: 100MHz, starts at 0
Vref (ref 0) vsource type=pulse val0=0 val1=0.9 period=10n rise=100p fall=100p width=5n

// Divided clock: 100MHz with 2.5ns phase offset (quarter period)
Vdiv (div 0) vsource type=pulse val0=0 val1=0.9 period=10n rise=100p fall=100p width=5n delay=2.5n

// DUT instance
I0 (vdd vss ref div up dn) pfd_updn

// Save signals
save ref div up dn

// Transient analysis
tran tran stop=300n maxstep=100p errpreset=conservative
