`include "constants.vams"
`include "disciplines.vams"

module pfd_updn (vdd, vss, ref, div, up, dn);
    inout electrical vdd, vss;
    input electrical ref, div;
    output electrical up, dn;

    parameter real vth = 0.45;
    parameter real tedge = 50p;

    integer up_state, dn_state;

    analog begin
        @(initial_step) begin
            up_state = 0;
            dn_state = 0;
        end

        // Rising edge on ref: set up high
        @(cross(V(ref) - vth, 1)) begin
            up_state = 1;
        end

        // Rising edge on div: set dn high
        @(cross(V(div) - vth, 1)) begin
            dn_state = 1;
        end

        // Combinational reset: when both are high, reset both to 0
        if ((up_state == 1) && (dn_state == 1)) begin
            up_state = 0;
            dn_state = 0;
        end

        // Drive outputs with transition
        V(up) <+ transition(up_state ? V(vdd) : V(vss), 0, tedge);
        V(dn) <+ transition(dn_state ? V(vdd) : V(vss), 0, tedge);
    end
endmodule
