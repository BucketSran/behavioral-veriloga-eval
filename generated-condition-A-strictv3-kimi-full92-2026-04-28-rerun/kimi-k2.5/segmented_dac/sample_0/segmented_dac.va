`include "constants.vams"
`include "disciplines.vams"

module segmented_dac(VDD, VSS, CLK, D13, D12, D11, D10, D9, D8, D7, D6, D5, D4, D3, D2, D1, D0, VOUT_P, VOUT_N);
    inout VDD, VSS;
    input CLK;
    input D13, D12, D11, D10, D9, D8, D7, D6, D5, D4, D3, D2, D1, D0;
    output VOUT_P, VOUT_N;

    electrical VDD, VSS, CLK;
    electrical D13, D12, D11, D10, D9, D8, D7, D6, D5, D4, D3, D2, D1, D0;
    electrical VOUT_P, VOUT_N;

    // Parameters
    parameter real vdd_nom = 1.8;
    parameter real vss_nom = 0.0;
    parameter real vth = 0.9;  // Clock threshold
    parameter real vstep = 1.0e-3;  // Voltage step per LSB (1mV per LSB)
    parameter real tdel = 0.0;
    parameter real trise = 100e-12;
    parameter real tfall = 100e-12;

    // Internal variables
    integer code_in;
    integer msb_therm;
    integer lsb_bin;
    integer i;
    integer thermometer_code;
    integer dac_value;
    real vout_p_val;
    real vout_n_val;
    real vcm;

    analog begin
        // Initialize
        @(initial_step) begin
            code_in = 0;
            msb_therm = 0;
            lsb_bin = 0;
            thermometer_code = 0;
            dac_value = 0;
            vout_p_val = vss_nom;
            vout_n_val = vss_nom;
        end

        // Sample on rising edge of CLK
        @(cross(V(CLK) - vth, 1)) begin
            // Read 14-bit input code
            code_in = 0;
            if (V(D13) > vth) code_in = code_in + 8192;
            if (V(D12) > vth) code_in = code_in + 4096;
            if (V(D11) > vth) code_in = code_in + 2048;
            if (V(D10) > vth) code_in = code_in + 1024;
            if (V(D9) > vth) code_in = code_in + 512;
            if (V(D8) > vth) code_in = code_in + 256;
            if (V(D7) > vth) code_in = code_in + 128;
            if (V(D6) > vth) code_in = code_in + 64;
            if (V(D5) > vth) code_in = code_in + 32;
            if (V(D4) > vth) code_in = code_in + 16;
            if (V(D3) > vth) code_in = code_in + 8;
            if (V(D2) > vth) code_in = code_in + 4;
            if (V(D1) > vth) code_in = code_in + 2;
            if (V(D0) > vth) code_in = code_in + 1;

            // Clip to valid range
            if (code_in > 16383) code_in = 16383;
            if (code_in < 0) code_in = 0;

            // Split into 6-bit MSB (thermometer) and 8-bit LSB (binary)
            // MSB: bits 13:8 (6 bits), LSB: bits 7:0 (8 bits)
            msb_therm = code_in >> 8;        // 6-bit MSB value (0-63)
            lsb_bin = code_in & 255;         // 8-bit LSB value (0-255)

            // Generate thermometer code for MSB (INL/DNL friendly)
            // 6-bit thermometer: 63 unary elements, msb_therm elements turned on
            thermometer_code = 0;
            for (i = 0; i < 63; i = i + 1) begin
                if (i < msb_therm) begin
                    thermometer_code = thermometer_code + 1;
                end
            end

            // Calculate DAC output value
            // Each thermometer element represents 256 LSBs (2^8)
            // Total DAC value = thermometer_code * 256 + lsb_bin
            dac_value = thermometer_code * 256 + lsb_bin;

            // Differential output: centered around vcm
            // Full scale: 0 to 16383 * vstep
            vcm = vdd_nom / 2.0;
            vout_p_val = vcm + (dac_value - 8192) * vstep / 2.0;
            vout_n_val = vcm - (dac_value - 8192) * vstep / 2.0;
        end

        // Output with transition
        V(VOUT_P) <+ transition(vout_p_val, tdel, trise, tfall);
        V(VOUT_N) <+ transition(vout_n_val, tdel, trise, tfall);
    end
endmodule
