`include "constants.vams"
`include "disciplines.vams"

module parameter_type_override_ref (out, vss);
    electrical out, vss;

    parameter real vhi = 0.5 from [0:inf);
    parameter integer reps = 2 from [0:inf);

    integer pulse_count;
    real out_val;

    analog begin
        @(initial_step) begin
            pulse_count = 0;
            out_val = 0.0;
        end

        // Generate pulses using timer events
        // Pulse period: 10ns, pulse width: 5ns
        if (pulse_count < reps) begin
            @(timer(10n * pulse_count + 1n)) begin
                out_val = vhi;
            end
            @(timer(10n * pulse_count + 6n)) begin
                out_val = 0.0;
                pulse_count = pulse_count + 1;
            end
        end

        V(out) <+ transition(out_val, 0, 100p);
        V(vss) <+ 0.0;
    end
endmodule
