`include "constants.vams"
`include "disciplines.vams"

module lfsr (dpn, vdd, vss, clk, en, rst_n);
    electrical dpn, vdd, vss, clk, en, rst_n;

    parameter real VHI = 0.9;
    parameter real VLO = 0.0;
    parameter real VTH = 0.45;
    parameter real T_RISE = 1n;
    parameter real T_FALL = 1n;
    parameter integer SEED = 16'hACE1;

    integer lfsr_reg;
    integer bit0;
    real dpn_out;

    analog begin
        @(initial_step) begin
            lfsr_reg = SEED;
            dpn_out = VLO;
        end

        @(cross(V(clk) - VTH, +1)) begin
            if (V(rst_n) < VTH) begin
                lfsr_reg = SEED;
                dpn_out = VLO;
            end else if (V(en) > VTH) begin
                bit0 = lfsr_reg & 1;
                lfsr_reg = (lfsr_reg >> 1) | ((bit0 ^ ((lfsr_reg >> 1) & 1) ^ ((lfsr_reg >> 3) & 1) ^ ((lfsr_reg >> 12) & 1)) << 15);
                dpn_out = (lfsr_reg & 1) ? VHI : VLO;
            end
        end

        V(dpn) <+ transition(dpn_out, 0, T_RISE, T_FALL);
        V(vdd) <+ VHI;
        V(vss) <+ VLO;
    end
endmodule
