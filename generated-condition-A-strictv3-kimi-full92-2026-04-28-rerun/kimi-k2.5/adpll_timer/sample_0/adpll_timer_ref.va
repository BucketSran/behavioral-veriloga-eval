`include "constants.vams"
`include "disciplines.vams"

module adpll_timer_ref (VDD, VSS, ref_clk, fb_clk, dco_clk, vctrl_mon, lock);
    inout electrical VDD, VSS;
    input electrical ref_clk;
    output electrical fb_clk, dco_clk, vctrl_mon, lock;

    // Parameters
    parameter integer div_ratio = 8;
    parameter real f_center = 760e6;
    parameter real freq_step_hz = 5e6;
    parameter real f_min = 500e6;
    parameter real f_max = 1.2e9;
    parameter integer code_min = 0;
    parameter integer code_max = 63;
    parameter integer code_center = 32;
    parameter integer code_init = 40;
    parameter real tedge = 1n;
    parameter real lock_tol = 12n;
    parameter integer lock_count_target = 4;

    // Internal state variables
    integer dco_code;
    integer div_counter;
    integer lock_count;
    real t_next_dco;
    real t_last_ref;
    real t_last_fb;
    real phase_error;
    real dco_period;
    real dco_freq;
    real vdd_val;
    real vss_val;
    real vth;
    real dco_clk_val;
    real fb_clk_val;
    real lock_val;
    real vctrl_val;

    // Local parameters
    localparam real ref_period = 20n; // 50 MHz reference

    analog begin
        // Initialization
        @(initial_step) begin
            dco_code = code_init;
            div_counter = 0;
            lock_count = 0;
            t_next_dco = $abstime + 0.5/f_center;
            t_last_ref = 0;
            t_last_fb = 0;
            phase_error = 0;
            dco_clk_val = 0;
            fb_clk_val = 0;
            lock_val = 0;
            vctrl_val = 0;
            vdd_val = 1.8;
            vss_val = 0;
            vth = 0.9;
        end

        // Get supply values
        vdd_val = V(VDD);
        vss_val = V(VSS);
        vth = 0.5 * (vdd_val + vss_val);

        // Calculate DCO frequency from code
        dco_freq = f_center + (dco_code - code_center) * freq_step_hz;
        if (dco_freq < f_min) dco_freq = f_min;
        if (dco_freq > f_max) dco_freq = f_max;
        dco_period = 1.0 / dco_freq;

        // DCO timer - toggle dco_clk
        @(timer(t_next_dco)) begin
            dco_clk_val = (dco_clk_val > vth) ? vss_val : vdd_val;
            t_next_dco = $abstime + 0.5 * dco_period;

            // Divide DCO edges to generate fb_clk
            if (dco_clk_val > vth) begin // rising edge of dco_clk
                div_counter = div_counter + 1;
                if (div_counter >= div_ratio) begin
                    div_counter = 0;
                    fb_clk_val = (fb_clk_val > vth) ? vss_val : vdd_val;
                    t_last_fb = $abstime;
                end
            end
        end

        // Detect reference clock edges
        @(cross(V(ref_clk) - vth, 1)) begin
            t_last_ref = $abstime;
        end

        // Phase detector - compare ref and fb edges
        // Simple bang-bang phase detector
        if (t_last_ref > 0 && t_last_fb > 0) begin
            phase_error = t_last_fb - t_last_ref;

            // Update DCO code based on phase error (simple PI-like behavior)
            // Only update periodically to allow convergence
            if ($abstime > t_last_ref + 0.5 * ref_period) begin
                if (phase_error > 0) begin
                    // fb is late, increase frequency
                    dco_code = dco_code - 1;
                end else if (phase_error < 0) begin
                    // fb is early, decrease frequency
                    dco_code = dco_code + 1;
                end

                // Clamp code
                if (dco_code < code_min) dco_code = code_min;
                if (dco_code > code_max) dco_code = code_max;
            end

            // Lock detection
            if (abs(phase_error) < lock_tol) begin
                lock_count = lock_count + 1;
                if (lock_count >= lock_count_target) begin
                    lock_count = lock_count_target; // saturate
                end
            end else begin
                lock_count = 0;
            end
        end

        // Set lock output
        if (lock_count >= lock_count_target) begin
            lock_val = vdd_val;
        end else begin
            lock_val = vss_val;
        end

        // Calculate normalized vctrl_mon (0 to 1 range)
        vctrl_val = vss_val + (vdd_val - vss_val) * (dco_code - code_min) / (code_max - code_min);
        if (vctrl_val < vss_val) vctrl_val = vss_val;
        if (vctrl_val > vdd_val) vctrl_val = vdd_val;

        // Drive outputs with transitions
        V(dco_clk) <+ transition(dco_clk_val, 0, tedge);
        V(fb_clk) <+ transition(fb_clk_val, 0, tedge);
        V(lock) <+ transition(lock_val, 0, tedge);
        V(vctrl_mon) <+ transition(vctrl_val, 0, tedge);
    end
endmodule
