`include "constants.vams"
`include "disciplines.vams"

module and2_gate (VDD, VSS, A, B, Y);
    inout electrical VDD, VSS;
    input electrical A, B;
    output electrical Y;

    parameter real vth = 0.5 from [0:inf);
    parameter real td = 0 from [0:inf);
    parameter real tr = 10p from (0:inf);
    parameter real tf = 10p from (0:inf);

    real yval;

    analog begin
        yval = (V(A) > vth && V(B) > vth) ? V(VDD) : V(VSS);
        V(Y) <+ transition(yval, td, tr, tf);
    end
endmodule
