`include "constants.vams"
`include "disciplines.vams"

module comp_flag (VDD, VSS, VIN, FLAG);
    inout VDD, VSS;
    input VIN;
    output FLAG;
    electrical VDD, VSS, VIN, FLAG;
    parameter real vth = 0.45;
    parameter real tdel = 0.0 from [0:inf);
    parameter real trise = 1n from (0:inf);
    parameter real tfall = 1n from (0:inf);

    integer flag_state;

    analog begin
        @(initial_step) begin
            flag_state = 0;
        end

        @(cross(V(VIN) - vth, 1)) begin
            flag_state = 1;
        end

        @(cross(V(VIN) - vth, -1)) begin
            flag_state = 0;
        end

        V(FLAG) <+ transition(flag_state * V(VDD), tdel, trise, tfall);
    end
endmodule
