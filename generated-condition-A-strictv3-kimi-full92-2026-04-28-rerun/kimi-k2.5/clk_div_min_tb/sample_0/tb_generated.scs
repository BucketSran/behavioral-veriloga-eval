simulator lang=spectre
global 0

// Power supplies
VDD (VDD 0) vsource dc=0.9
VSS (VSS 0) vsource dc=0

// Clock input: 2GHz (period = 0.5ns) for sufficient edges
VCLK (CLK 0) vsource type=pulse val0=0 val1=0.9 period=0.5n rise=20p fall=20p width=230p

// Active-low reset: start low, release at 2ns
VRST_N (RST_N 0) vsource type=pwl wave=[0 0 2n 0 2.01n 0.9]

// Transient analysis
tran tran stop=24n maxstep=20p

// Save public waveforms
save CLK RST_N CLK_OUT

// Include DUT
ahdl_include "clk_div_min.va"

// DUT instance
XDUT (VDD VSS CLK RST_N CLK_OUT) clk_div_min
