`include "constants.vams"
`include "disciplines.vams"

module xor_phase_detector (vdd, vss, ref, div, pd_out);
    inout electrical vdd, vss;
    input electrical ref, div;
    output electrical pd_out;

    parameter real vth = 0.45 from (0:inf);
    parameter real tedge = 50p from (0:inf);

    integer ref_state;
    integer div_state;
    integer pd_state;

    analog begin
        @(initial_step) begin
            ref_state = 0;
            div_state = 0;
            pd_state = 0;
        end

        @(cross(V(ref) - vth, 1)) begin
            ref_state = 1;
        end
        @(cross(V(ref) - vth, -1)) begin
            ref_state = 0;
        end

        @(cross(V(div) - vth, 1)) begin
            div_state = 1;
        end
        @(cross(V(div) - vth, -1)) begin
            div_state = 0;
        end

        // XOR: output is HIGH when inputs are different
        if (ref_state != div_state) begin
            pd_state = 1;
        end else begin
            pd_state = 0;
        end

        if (pd_state == 1) begin
            V(pd_out) <+ transition(V(vdd), 0, tedge);
        end else begin
            V(pd_out) <+ transition(V(vss), 0, tedge);
        end
    end
endmodule
