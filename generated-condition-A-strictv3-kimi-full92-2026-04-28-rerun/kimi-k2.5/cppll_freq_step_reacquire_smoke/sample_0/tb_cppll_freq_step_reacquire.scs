// tb_cppll_freq_step_reacquire.scs
// Minimal EVAS-compatible testbench for CPPLL timer-based model

simulator lang=spectre

// Include Verilog-A module
ahdl_include "cppll_timer_ref.va"

// Supply voltages
VDD (VDD 0) vsource dc=1.8
VSS (VSS 0) vsource dc=0

// Reference clock: 50 MHz for first 2us, then step to ~51.28 MHz (19.5ns period)
// Using PWL to create frequency step
Vref (ref_clk 0) vsource type=pwl wave=[0 0 10n 1.8 20n 0 30n 1.8 40n 0 50n 1.8 \
    60n 0 70n 1.8 80n 0 90n 1.8 100n 0 110n 1.8 120n 0 130n 1.8 140n 0 \
    150n 1.8 160n 0 170n 1.8 180n 0 190n 1.8 200n 0 \
    210n 1.8 220n 0 230n 1.8 240n 0 250n 1.8 260n 0 270n 1.8 280n 0 \
    290n 1.8 300n 0 310n 1.8 320n 0 330n 1.8 340n 0 350n 1.8 360n 0 \
    370n 1.8 380n 0 390n 1.8 400n 0 \
    // Continue 50 MHz until 2us = 2000ns \
    // Then switch to 51.28 MHz (period = 19.5ns) \
    2000n 0 2009.75n 1.8 2019.5n 0 2029.25n 1.8 2039n 0 \
    2048.75n 1.8 2058.5n 0 2068.25n 1.8 2078n 0 2087.75n 1.8 2097.5n 0 \
    2107.25n 1.8 2117n 0 2126.75n 1.8 2136.5n 0 2146.25n 1.8 2156n 0 \
    2165.75n 1.8 2175.5n 0 2185.25n 1.8 2195n 0 2204.75n 1.8 2214.5n 0 \
    2224.25n 1.8 2234n 0 2243.75n 1.8 2253.5n 0 2263.25n 1.8 2273n 0 \
    2282.75n 1.8 2292.5n 0 2302.25n 1.8 2312n 0 2321.75n 1.8 2331.5n 0 \
    2341.25n 1.8 2351n 0 2360.75n 1.8 2370.5n 0 2380.25n 1.8 2390n 0 \
    2399.75n 1.8 2409.5n 0 2419.25n 1.8 2429n 0 2438.75n 1.8 2448.5n 0 \
    2458.25n 1.8 2468n 0 2477.75n 1.8 2487.5n 0 2497.25n 1.8 2507n 0 \
    2516.75n 1.8 2526.5n 0 2536.25n 1.8 2546n 0 2555.75n 1.8 2565.5n 0 \
    2575.25n 1.8 2585n 0 2594.75n 1.8 2604.5n 0 2614.25n 1.8 2624n 0 \
    2633.75n 1.8 2643.5n 0 2653.25n 1.8 2663n 0 2672.75n 1.8 2682.5n 0 \
    2692.25n 1.8 2702n 0 2711.75n 1.8 2721.5n 0 2731.25n 1.8 2741n 0 \
    2750.75n 1.8 2760.5n 0 2770.25n 1.8 2780n 0 2789.75n 1.8 2799.5n 0 \
    2809.25n 1.8 2819n 0 2828.75n 1.8 2838.5n 0 2848.25n 1.8 2858n 0 \
    2867.75n 1.8 2877.5n 0 2887.25n 1.8 2897n 0 2906.75n 1.8 2916.5n 0 \
    2926.25n 1.8 2936n 0 2945.75n 1.8 2955.5n 0 2965.25n 1.8 2975n 0 \
    2984.75n 1.8 2994.5n 0 3004.25n 1.8 3014n 0 3023.75n 1.8 3033.5n 0 \
    3043.25n 1.8 3053n 0 3062.75n 1.8 3072.5n 0 3082.25n 1.8 3092n 0 \
    3101.75n 1.8 3111.5n 0 3121.25n 1.8 3131n 0 3140.75n 1.8 3150.5n 0 \
    3160.25n 1.8 3170n 0 3179.75n 1.8 3189.5n 0 3199.25n 1.8 3209n 0 \
    3218.75n 1.8 3228.5n 0 3238.25n 1.8 3248n 0 3257.75n 1.8 3267.5n 0 \
    3277.25n 1.8 3287n 0 3296.75n 1.8 3306.5n 0 3316.25n 1.8 3326n 0 \
    3335.75n 1.8 3345.5n 0 3355.25n 1.8 3365n 0 3374.75n 1.8 3384.5n 0 \
    3394.25n 1.8 3404n 0 3413.75n 1.8 3423.5n 0 3433.25n 1.8 3443n 0 \
    3452.75n 1.8 3462.5n 0 3472.25n 1.8 3482n 0 3491.75n 1.8 3501.5n 0 \
    3511.25n 1.8 3521n 0 3530.75n 1.8 3540.5n 0 3550.25n 1.8 3560n 0 \
    3569.75n 1.8 3579.5n 0 3589.25n 1.8 3599n 0 3608.75n 1.8 3618.5n 0 \
    3628.25n 1.8 3638n 0 3647.75n 1.8 3657.5n 0 3667.25n 1.8 3677n 0 \
    3686.75n 1.8 3696.5n 0 3706.25n 1.8 3716n 0 3725.75n 1.8 3735.5n 0 \
    3745.25n 1.8 3755n 0 3764.75n 1.8 3774.5n 0 3784.25n 1.8 3794n 0 \
    3803.75n 1.8 3813.5n 0 3823.25n 1.8 3833n 0 3842.75n 1.8 3852.5n 0 \
    3862.25n 1.8 3872n 0 3881.75n 1.8 3891.5n 0 3901.25n 1.8 3911n 0 \
    3920.75n 1.8 3930.5n 0 3940.25n 1.8 3950n 0 3959.75n 1.8 3969.5n 0 \
    3979.25n 1.8 3989n 0 3998.75n 1.8 4008.5n 0 4018.25n 1.8 4028n 0 \
    4037.75n 1.8 4047.5n 0 4057.25n 1.8 4067n 0 4076.75n 1.8 4086.5n 0 \
    4096.25n 1.8 4106n 0 4115.75n 1.8 4125.5n 0 4135.25n 1.8 4145n 0 \
    4154.75n 1.8 4164.5n 0 4174.25n 1.8 4184n 0 4193.75n 1.8 4203.5n 0 \
    4213.25n 1.8 4223n 0 4232.75n 1.8 4242.5n 0 4252.25n 1.8 4262n 0 \
    4271.75n 1.8 4281.5n 0 4291.25n 1.8 4301n 0 4310.75n 1.8 4320.5n 0 \
    4330.25n 1.8 4340n 0 4349.75n 1.8 4359.5n 0 4369.25n 1.8 4379n 0 \
    4388.75n 1.8 4398.5n 0 4408.25n 1.8 4418n 0 4427.75n 1.8 4437.5n 0 \
    4447.25n 1.8 4457n 0 4466.75n 1.8 4476.5n 0 4486.25n 1.8 4496n 0 \
    4505.75n 1.8 4515.5n 0 4525.25n 1.8 4535n 0 4544.75n 1.8 4554.5n 0 \
    4564.25n 1.8 4574n 0 4583.75n 1.8 4593.5n 0 4603.25n 1.8 4613n 0 \
    4622.75n 1.8 4632.5n 0 4642.25n 1.8 4652n 0 4661.75n 1.8 4671.5n 0 \
    4681.25n 1.8 4691n 0 4700.75n 1.8 4710.5n 0 4720.25n 1.8 4730n 0 \
    4739.75n 1.8 4749.5n 0 4759.25n 1.8 4769n 0 4778.75n 1.8 4788.5n 0 \
    4798.25n 1.8 4808n 0 4817.75n 1.8 4827.5n 0 4837.25n 1.8 4847n 0 \
    4856.75n 1.8 4866.5n 0 4876.25n 1.8 4886n 0 4895.75n 1.8 4905.5n 0 \
    4915.25n 1.8 4925n 0 4934.75n 1.8 4944.5n 0 4954.25n 1.8 4964n 0 \
    4973.75n 1.8 4983.5n 0 4993.25n 1.8 5003n 0 5012.75n 1.8 5022.5n 0 \
    5032.25n 1.8 5042n 0 5051.75n 1.8 5061.5n 0 5071.25n 1.8 5081n 0 \
    5090.75n 1.8 5100.5n 0 5110.25n 1.8 5120n 0 5129.75n 1.8 5139.5n 0 \
    5149.25n 1.8 5159n 0 5168.75n 1.8 5178.5n 0 5188.25n 1.8 5198n 0 \
    5207.75n 1.8 5217.5n 0 5227.25n 1.8 5237n 0 5246.75n 1.8 5256.5n 0 \
    5266.25n 1.8 5276n 0 5285.75n 1.8 5295.5n 0 5305.25n 1.8 5315n 0 \
    5324.75n 1.8 5334.5n 0 5344.25n 1.8 5354n 0 5363.75n 1.8 5373.5n 0 \
    5383.25n 1.8 5393n 0 5402.75n 1.8 5412.5n 0 5422.25n 1.8 5432n 0 \
    5441.75n 1.8 5451.5n 0 5461.25n 1.8 5471n 0 5480.75n 1.8 5490.5n 0 \
    5500.25n 1.8 5510n 0 5519.75n 1.8 5529.5n 0 5539.25n 1.8 5549n 0 \
    5558.75n 1.8 5568.5n 0 5578.25n 1.8 5588n 0 5597.75n 1.8 5607.5n 0 \
    5617.25n 1.8 5627n 0 5636.75n 1.8 5646.5n 0 5656.25n 1.8 5666n 0 \
    5675.75n 1.8 5685.5n 0 5695.25n 1.8 5705n 0 5714.75n 1.8 5724.5n 0 \
    5734.25n 1.8 5744n 0 5753.75n 1.8 5763.5n 0 5773.25n 1.8 5783n 0 \
    5792.75n 1.8 5802.5n 0 5812.25n 1.8 5822n 0 5831.75n 1.8 5841.5n 0 \
    5851.25n 1.8 5861n 0 5870.75n 1.8 5880.5n 0 5890.25n 1.8 5900n 0 \
    5909.75n 1.8 5919.5n 0 5929.25n 1.8 5939n 0 5948.75n 1.8 5958.5n 0 \
    5968.25n 1.8 5978n 0 5987.75n 1.8 5997.5n 0]

// DUT instance
dut (VDD VSS ref_clk fb_clk dco_clk vctrl_mon lock) cppll_timer_ref

// Transient analysis
tran tran stop=6u maxstep=5n errpreset=conservative

// Save statements for required waveforms
save ref_clk
save fb_clk
save lock
save vctrl_mon
