// PFD near-deadzone stress: tiny fixed phase offset should produce short UP pulses.
simulator lang=spectre
global 0

Vvdd (vdd 0) vsource dc=0.9 type=dc
Vvss (vss 0) vsource dc=0.0 type=dc

// REF leads DIV by only 100ps: this stresses short-pulse reset behavior.
Vref (ref 0) vsource type=pulse val0=0 val1=0.9 period=20n width=10n rise=20p fall=20p
Vdiv (div 0) vsource type=pulse val0=0 val1=0.9 period=20n delay=100p width=10n rise=20p fall=20p

IDUT (vdd vss ref div up dn) pfd_updn vth=0.45 tedge=20p

simulatorOptions options reltol=1e-4 vabstol=1e-6 iabstol=1e-12 temp=27 tnom=27 gmin=1e-12

tran tran stop=300n maxstep=5p errpreset=conservative
save ref div up dn

ahdl_include "./pfd_updn.va"
