// vaEvas/tb_serializer_8b/schematic
simulator lang=spectre
global 0

// Power
Vvdd (vdd 0) vsource dc=0.9 type=dc
Vvss (vss 0) vsource dc=0.0 type=dc

// Parallel data: 0xA5 = 1010_0101
// D7=1 D6=0 D5=1 D4=0 D3=0 D2=1 D1=0 D0=1
Vd7 (d7 0) vsource dc=0.9 type=dc
Vd6 (d6 0) vsource dc=0.0 type=dc
Vd5 (d5 0) vsource dc=0.9 type=dc
Vd4 (d4 0) vsource dc=0.0 type=dc
Vd3 (d3 0) vsource dc=0.0 type=dc
Vd2 (d2 0) vsource dc=0.9 type=dc
Vd1 (d1 0) vsource dc=0.0 type=dc
Vd0 (d0 0) vsource dc=0.9 type=dc

// LOAD: pulse high for one CLK period to latch data
Vload (load 0) vsource type=pulse val0=0 val1=0.9 period=200n delay=5n width=15n rise=100p fall=100p

// CLK: 200MHz serial clock
Vclk (clk 0) vsource type=pulse val0=0 val1=0.9 period=5n width=2.5n rise=100p fall=100p delay=10n

// DUT (port order: VDD VSS D7..D0 LOAD CLK SOUT)
IDUT (vdd vss d7 d6 d5 d4 d3 d2 d1 d0 load clk sout) serializer_8b vth=0.45 tedge=100p

simulatorOptions options reltol=1e-4 temp=27

tran tran stop=300n maxstep=200p errpreset=conservative

save load clk sout d7 d0

ahdl_include "./serializer_8b.va"
