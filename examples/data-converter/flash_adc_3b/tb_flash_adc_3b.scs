// vaEvas/tb_flash_adc_3b/schematic
simulator lang=spectre
global 0

// Power
Vvdd (vdd 0) vsource dc=0.9 type=dc
Vvss (vss 0) vsource dc=0.0 type=dc

// Analog input: ramp 0 -> 0.9V over 800ns
Vvin (vin 0) vsource type=pwl wave=[0 0 800e-9 0.9]

// Clock: 100MHz
Vclk (clk 0) vsource type=pulse val0=0 val1=0.9 period=10n width=5n rise=100p fall=100p

// DUT (port order: VDD VSS VIN CLK DOUT2 DOUT1 DOUT0)
IDUT (vdd vss vin clk dout2 dout1 dout0) flash_adc_3b vrefp=0.9 vrefn=0.0 vth=0.45 tedge=100p

simulatorOptions options reltol=1e-4 temp=27

tran tran stop=820n maxstep=500p errpreset=conservative

save vin clk dout2 dout1 dout0

ahdl_include "./flash_adc_3b.va"
