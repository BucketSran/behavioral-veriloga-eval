`include "disciplines.vams"
module cdac_8b_monodown(vin, clks, dctrl0, dctrl1, dctrl2, dctrl3, dctrl4, dctrl5, dctrl6, dctrl7, vres);
input vin, clks, dctrl0, dctrl1, dctrl2, dctrl3, dctrl4, dctrl5, dctrl6, dctrl7;
output vres;
electrical vin, clks, dctrl0, dctrl1, dctrl2, dctrl3, dctrl4, dctrl5, dctrl6, dctrl7, vres;
analog begin
    V(vres) <+ 0.0;
end
endmodule
