// Starter stub for differential_vco_clip_idtmod.
// Same module signature, clip macro, and parameters as the solution; the analog
// body is a placeholder that the candidate implementation must replace.

`include "constants.vams"
`include "disciplines.vams"

`define clip(x, LO, HI) ((x < LO) ? LO : (x > HI) ? HI : x)

module differential_vco_clip_idtmod (
    input  electrical vinp,
    input  electrical vinm,
    output electrical outp,
    output electrical outm,
    output electrical metric
);
    parameter real Fnom = 20.0e6 from (0:inf);
    parameter real dFdV = 160.0e6 exclude 0.0;
    parameter real Fmin = 5.0e6 from (0:inf);
    parameter real Fmax = 80.0e6 from (0:inf);
    parameter real Vcm = 0.45;
    parameter real Vac = 0.4 from (0:inf);

    analog begin
        // TODO: implement the clipped idtmod phase integrator and differential sine outputs.
        V(outp) <+ 0.0;
        V(outm) <+ 0.0;
        V(metric) <+ 0.0;
    end
endmodule
