// Spectre testbench for serializer_8b

// Include the Verilog-A model
ahdl_include "serializer_8b.va"

// Supply voltages
v_vdd (vdd 0) vsource dc=0.9
v_vss (vss 0) vsource dc=0

// Parallel data inputs - set to 0xA5 = 10100101
// d7=1, d6=0, d5=1, d4=0, d3=0, d2=1, d1=0, d0=1
v_d7 (d7 0) vsource dc=0.9
v_d6 (d6 0) vsource dc=0
v_d5 (d5 0) vsource dc=0.9
v_d4 (d4 0) vsource dc=0
v_d3 (d3 0) vsource dc=0
v_d2 (d2 0) vsource dc=0.9
v_d1 (d1 0) vsource dc=0
v_d0 (d0 0) vsource dc=0.9

// Load pulse - active high, pulse at start
v_load (load 0) vsource type=pulse val0=0 val1=0.9 period=100n delay=5n rise=100p fall=100p width=10n

// Clock - 5ns period (200MHz), starts after load
v_clk (clk 0) vsource type=pulse val0=0 val1=0.9 period=5n delay=20n rise=100p fall=100p width=2.5n

// Device under test
dut (vdd vss d7 d6 d5 d4 d3 d2 d1 d0 load clk sout) serializer_8b tedge=10p

// Save signals for EVAS checker
save load clk sout d7 d6 d5 d4 d3 d2 d1 d0

// Transient analysis - strict EVAS settings
tran tran stop=300n maxstep=1n
