simulator lang=spectre
global 0

// Supply rails
Vvdd (VDD 0) vsource dc=0.9
Vvss (VSS 0) vsource dc=0

// Clock: 1GHz (1ns period), 50% duty cycle
Vclk (CLK 0) vsource type=pulse val0=0 val1=0.9 period=1n rise=10p fall=10p width=490p

// Digital inputs: 4-bit code ramp 0->15 over 16 clock cycles (16ns)
// Code 0 (0000): 0-1ns
// Code 1 (0001): 1-2ns
// Code 2 (0010): 2-3ns
// Code 3 (0011): 3-4ns
// Code 4 (0100): 4-5ns
// Code 5 (0101): 5-6ns
// Code 6 (0110): 6-7ns
// Code 7 (0111): 7-8ns
// Code 8 (1000): 8-9ns
// Code 9 (1001): 9-10ns
// Code 10 (1010): 10-11ns
// Code 11 (1011): 11-12ns
// Code 12 (1100): 12-13ns
// Code 13 (1101): 13-14ns
// Code 14 (1110): 14-15ns
// Code 15 (1111): 15-16ns

// DIN3 (MSB): codes 8-15 high
Vdin3 (DIN3 0) vsource type=pwl wave=[0n 0 8n 0 8.001n 0.9 16n 0.9]

// DIN2: codes 4-7, 12-15 high
Vdin2 (DIN2 0) vsource type=pwl wave=[0n 0 4n 0 4.001n 0.9 8n 0.9 8.001n 0 12n 0 12.001n 0.9 16n 0.9]

// DIN1: codes 2-3, 6-7, 10-11, 14-15 high
Vdin1 (DIN1 0) vsource type=pwl wave=[0n 0 2n 0 2.001n 0.9 4n 0.9 4.001n 0 6n 0 6.001n 0.9 8n 0.9 8.001n 0 10n 0 10.001n 0.9 12n 0.9 12.001n 0 14n 0 14.001n 0.9 16n 0.9]

// DIN0 (LSB): odd codes high
Vdin0 (DIN0 0) vsource type=pwl wave=[0n 0 1n 0 1.001n 0.9 2n 0.9 2.001n 0 3n 0 3.001n 0.9 4n 0.9 4.001n 0 5n 0 5.001n 0.9 6n 0.9 6.001n 0 7n 0 7.001n 0.9 8n 0.9 8.001n 0 9n 0 9.001n 0.9 10n 0.9 10.001n 0 11n 0 11.001n 0.9 12n 0.9 12.001n 0 13n 0 13.001n 0.9 14n 0.9 14.001n 0 15n 0 15.001n 0.9 16n 0.9]

// DUT instantiation by position: (VDD, VSS, DIN3, DIN2, DIN1, DIN0, CLK, AOUT)
XDUT (VDD VSS DIN3 DIN2 DIN1 DIN0 CLK AOUT) dac_ramp_ref

// Transient analysis
tran tran stop=68n maxstep=20p

// Save signals
save VDD VSS DIN3 DIN2 DIN1 DIN0 CLK AOUT

ahdl_include "dac_ramp_ref.va"
