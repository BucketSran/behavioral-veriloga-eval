`include "constants.vams"
`include "disciplines.vams"

module cross_interval_163p333_ref(VDD, VSS, a, b, delay_out, seen_out);
    inout electrical VDD, VSS;
    input electrical a, b;
    output electrical delay_out, seen_out;

    integer state;
    real t_a, t_b;
    real delay_ps;
    real vdd_val;
    real delay_out_target;
    real seen_out_target;

    analog begin
        @(initial_step) begin
            state = 0;
            t_a = 0.0;
            t_b = 0.0;
            delay_ps = 0.0;
        end

        // Wait for rising cross on a at 0.45V
        @(cross(V(a) - 0.45, +1)) begin
            if (state == 0) begin
                t_a = $abstime;
                state = 1;
            end
        end

        // Wait for rising cross on b at 0.45V
        @(cross(V(b) - 0.45, +1)) begin
            if (state == 1) begin
                t_b = $abstime;
                state = 2;
            end
        end

        // Calculate delay in ps
        if (state >= 2) begin
            delay_ps = (t_b - t_a) * 1.0e12; // convert to ps
        end

        // Get VDD value
        vdd_val = V(VDD);

        // Compute delay_out target
        delay_out_target = vdd_val * delay_ps / 200.0;

        // Compute seen_out target
        if (state >= 2) begin
            seen_out_target = vdd_val;
        end else begin
            seen_out_target = 0.0;
        end

        // Output delay_out = VDD * delay_ps / 200
        V(delay_out) <+ transition(delay_out_target, 0, 1p);

        // Output seen_out: HIGH after both crossings observed
        V(seen_out) <+ transition(seen_out_target, 0, 1p);
    end
endmodule
