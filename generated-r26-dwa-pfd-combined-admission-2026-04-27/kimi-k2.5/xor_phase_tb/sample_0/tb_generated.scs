simulator lang=spectre
global 0

// Supply rails
Vvdd (VDD 0) vsource dc=0.9
Vvss (VSS 0) vsource dc=0

// Reference clock: 100MHz, 50% duty, starts at 0
Vref (ref 0) vsource type=pulse val0=0 val1=0.9 period=10n delay=0 rise=100p fall=100p width=5n

// Divided clock: 100MHz, 50% duty, 2.5ns phase offset (90 degrees)
Vdiv (div 0) vsource type=pulse val0=0 val1=0.9 period=10n delay=2.5n rise=100p fall=100p width=5n

// DUT instantiation by position
XDUT (VDD, VSS, ref, div, pd_out) xor_phase_ref

// Transient analysis
tran tran stop=80n maxstep=50p

// Save signals
save VDD VSS ref div pd_out

// AHDL include last
ahdl_include "xor_phase_ref.va"
