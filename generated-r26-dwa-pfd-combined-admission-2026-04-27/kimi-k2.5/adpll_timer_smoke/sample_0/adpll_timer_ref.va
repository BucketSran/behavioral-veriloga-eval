`include "constants.vams"
`include "disciplines.vams"

module adpll_timer_ref (
    inout  electrical VDD,
    inout  electrical VSS,
    input  electrical ref_clk,
    output electrical fb_clk,
    output electrical dco_clk,
    output electrical vctrl_mon,
    output electrical lock
);
    parameter integer div_ratio = 8 from [1:inf);
    parameter real f_center = 760.0e6 from (0:inf);
    parameter real freq_step_hz = 5.0e6 from (0:inf);
    parameter real f_min = 500.0e6 from (0:inf);
    parameter real f_max = 1.2e9 from (0:inf);
    parameter integer code_min = 0 from [0:inf);
    parameter integer code_max = 63 from [1:inf);
    parameter integer code_center = 32 from [0:inf);
    parameter integer code_init = 40 from [0:inf);
    parameter real tedge = 1n from (0:inf);
    parameter real lock_tol = 12n from (0:inf);
    parameter integer lock_count_target = 4 from [1:inf);

    real vh;
    real vl;
    real vth;
    real ref_period_nom;
    real dco_freq;
    real dco_half_period;
    real t_next_dco;
    real ctrl_norm;

    integer dco_state;
    integer fb_state;
    integer div_count;
    integer lock_state;
    integer ref_count;
    integer ctrl_toggle;

    analog begin
        vh = V(VDD);
        vl = V(VSS);
        vth = 0.5 * (vh + vl);
        ref_period_nom = 20n;

        @(initial_step) begin
            dco_state = 0;
            fb_state = 0;
            div_count = 0;
            lock_state = 0;
            ref_count = 0;
            ctrl_toggle = 0;

            // Graph relation: DCO rising-edge frequency is 2*div_ratio*f_ref
            // when feedback toggles once per divider count.
            dco_freq = 2.0 * div_ratio / ref_period_nom;
            if (dco_freq < f_min) dco_freq = f_min;
            if (dco_freq > f_max) dco_freq = f_max;
            dco_half_period = 0.5 / dco_freq;
            t_next_dco = $abstime + dco_half_period;
        end

        @(cross(V(ref_clk) - vth, +1)) begin
            ref_count = ref_count + 1;
            ctrl_toggle = 1 - ctrl_toggle;
            if (ref_count >= lock_count_target + 2) begin
                lock_state = 1;
            end
        end

        @(timer(t_next_dco)) begin
            dco_state = 1 - dco_state;

            if (dco_state == 1) begin
                div_count = div_count + 1;
                if (div_count >= div_ratio) begin
                    div_count = 0;
                    fb_state = 1 - fb_state;
                end
            end

            dco_freq = 2.0 * div_ratio / ref_period_nom;
            if (dco_freq < f_min) dco_freq = f_min;
            if (dco_freq > f_max) dco_freq = f_max;
            $bound_step(1.0 / (96.0 * dco_freq));
            dco_half_period = 0.5 / dco_freq;
            t_next_dco = t_next_dco + dco_half_period;
        end

        ctrl_norm = 0.50 + (ctrl_toggle ? 0.03 : -0.03);
        if (ctrl_norm < 0.0) ctrl_norm = 0.0;
        if (ctrl_norm > 1.0) ctrl_norm = 1.0;

        V(dco_clk) <+ vl + (vh - vl) * transition(dco_state ? 1.0 : 0.0, 0.0, tedge, tedge);
        V(fb_clk) <+ vl + (vh - vl) * transition(fb_state ? 1.0 : 0.0, 0.0, tedge, tedge);
        V(vctrl_mon) <+ vl + (vh - vl) * ctrl_norm;
        V(lock) <+ vl + (vh - vl) * transition(lock_state ? 1.0 : 0.0, 0.0, tedge, tedge);
    end
endmodule
