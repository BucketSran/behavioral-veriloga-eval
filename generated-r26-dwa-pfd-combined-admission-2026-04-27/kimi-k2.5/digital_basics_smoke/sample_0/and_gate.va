`include "constants.vams"
`include "disciplines.vams"

module and_gate (input A, input B, output Y);
    electrical A, B, Y;
    real vdd_val, vss_val, vth, out_val;
    real tr, tf;

    analog begin
        @(initial_step) begin
            vdd_val = 1.0;
            vss_val = 0.0;
            tr = 100p;
            tf = 100p;
        end

        vth = (vdd_val + vss_val) / 2.0;

        if ((V(A) > vth) && (V(B) > vth)) begin
            out_val = vdd_val;
        end else begin
            out_val = vss_val;
        end

        V(Y) <+ transition(out_val, 0, tr, tf);
    end
endmodule
