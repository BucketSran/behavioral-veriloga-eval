simulator lang=spectre
global 0

// Supply voltages
Vvdd (VDD 0) vsource dc=0.9
Vvss (VSS 0) vsource dc=0

// Clock stimulus: 100MHz clock (10ns period), 50% duty cycle
Vclk (clk 0) vsource type=pulse val0=0 val1=0.9 period=10n rise=100p fall=100p width=5n

// Analog input: ramp from 0 to 0.9V over 140ns to inspect capture timing
Vvin (vin 0) vsource type=pwl wave=[0 0 140n 0.9]

// DUT instantiation by position
XDUT (VDD, VSS, clk, vin, vout) sample_hold_aperture_ref

// Transient analysis
tran tran stop=140n maxstep=100p

// Save waveforms for inspection
save VDD VSS clk vin vout

ahdl_include "sample_hold_aperture_ref.va"
