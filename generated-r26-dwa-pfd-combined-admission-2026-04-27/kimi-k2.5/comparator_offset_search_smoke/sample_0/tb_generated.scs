// Spectre testbench for comparator_offset_search_ref

// Include the Verilog-A model
ahdl_include "comparator_offset_search_ref.va"

// Supply voltages
v_vdd (vdd 0) vsource dc=1.0
v_vss (vss 0) vsource dc=0.0

// Reference input at 0.5V
v_inn (inn 0) vsource dc=0.5

// Input ramp: sweep from 0.4V to 0.6V over 100ns
v_inp (inp 0) vsource dc=0.4 type=pwl wave=[0 0.4 100n 0.6]

// DUT instance
dut (vdd vss inp inn outp) comparator_offset_search_ref

// Transient analysis with ramp input
tran tran stop=100n maxstep=100p errpreset=conservative

// Save signals for CSV output - exact names required by checker
save inp inn outp
