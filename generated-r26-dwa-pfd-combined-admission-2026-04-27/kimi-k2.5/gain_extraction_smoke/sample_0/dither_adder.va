`include "constants.vams"
`include "disciplines.vams"

module dither_adder (vinp, vinn, dpn, vdin_p, vdin_n);
    input vinp, vinn, dpn;
    output vdin_p, vdin_n;
    electrical vinp, vinn, dpn, vdin_p, vdin_n;

    parameter real DITHER_AMP = 0.014063;
    parameter real VDD = 0.9;
    parameter real CLK_TH = 0.45;
    parameter real TR = 1n;
    parameter real TF = 1n;

    real vin_p_val, vin_n_val, dpn_val;
    real vout_p, vout_n;

    analog begin
        vin_p_val = V(vinp);
        vin_n_val = V(vinn);
        dpn_val = V(dpn);

        if (dpn_val > CLK_TH) begin
            vout_p = vin_p_val + DITHER_AMP;
            vout_n = vin_n_val - DITHER_AMP;
        end else begin
            vout_p = vin_p_val - DITHER_AMP;
            vout_n = vin_n_val + DITHER_AMP;
        end

        V(vdin_p) <+ transition(vout_p, 0, TR, TF);
        V(vdin_n) <+ transition(vout_n, 0, TR, TF);
    end
endmodule
