`include "constants.vams"
`include "disciplines.vams"

module bin4_out (VDD, VSS, CODE, DOUT);
    inout VDD, VSS;
    input [3:0] CODE;
    output [3:0] DOUT;
    electrical VDD, VSS;
    electrical [3:0] CODE, DOUT;
    parameter real vth = 0.45;
    parameter real tedge = 20p;
    genvar i;

    analog begin
        for (i = 0; i < 4; i = i + 1) begin
            V(DOUT[i]) <+ transition((V(CODE[i]) > vth) ? V(VDD) : V(VSS), 0.0, tedge, tedge);
        end
    end
endmodule
