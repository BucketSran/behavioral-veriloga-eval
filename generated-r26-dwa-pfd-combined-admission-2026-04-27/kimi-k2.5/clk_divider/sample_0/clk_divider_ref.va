`include "constants.vams"
`include "disciplines.vams"

module clk_divider_ref (
    clk_in,
    rst_n,
    div_code_0,
    div_code_1,
    div_code_2,
    div_code_3,
    div_code_4,
    div_code_5,
    div_code_6,
    div_code_7,
    clk_out,
    lock
);

    input clk_in;
    input rst_n;
    input div_code_0;
    input div_code_1;
    input div_code_2;
    input div_code_3;
    input div_code_4;
    input div_code_5;
    input div_code_6;
    input div_code_7;
    output clk_out;
    output lock;

    electrical clk_in;
    electrical rst_n;
    electrical div_code_0;
    electrical div_code_1;
    electrical div_code_2;
    electrical div_code_3;
    electrical div_code_4;
    electrical div_code_5;
    electrical div_code_6;
    electrical div_code_7;
    electrical clk_out;
    electrical lock;

    parameter real vth = 0.45;
    parameter real vhigh = 0.9;
    parameter real vlow = 0.0;
    parameter real trf = 10p;

    integer ratio;
    integer counter;
    integer out_state;
    integer lock_state;
    integer edge_count;
    integer low_len;
    integer high_len;
    integer segment_len;

    analog begin
        @(initial_step) begin
            ratio = 1;
            counter = 0;
            out_state = 0;
            lock_state = 0;
            edge_count = 0;
            low_len = 1;
            high_len = 1;
            segment_len = 1;
        end

        @(cross(V(clk_in) - vth, +1)) begin

            ratio = (V(div_code_0) > vth ? 1 : 0)
                  + (V(div_code_1) > vth ? 2 : 0)
                  + (V(div_code_2) > vth ? 4 : 0)
                  + (V(div_code_3) > vth ? 8 : 0)
                  + (V(div_code_4) > vth ? 16 : 0)
                  + (V(div_code_5) > vth ? 32 : 0)
                  + (V(div_code_6) > vth ? 64 : 0)
                  + (V(div_code_7) > vth ? 128 : 0);
            if (ratio < 1)
                ratio = 1;

            if (V(rst_n) < vth) begin
                counter = 0;
                out_state = 0;
                lock_state = 0;
                edge_count = 0;
                segment_len = 1;
            end else if (ratio == 1) begin
                out_state = 1;
                lock_state = 1;
                counter = 0;
                edge_count = edge_count + 1;
            end else begin
                low_len = (ratio + 1) / 2;
                high_len = ratio - ((ratio + 1) / 2);
                if (low_len < 1)
                    low_len = 1;
                if (high_len < 1)
                    high_len = 1;

                if (counter <= 0)
                    counter = (out_state == 0) ? low_len : high_len;

                counter = counter - 1;
                edge_count = edge_count + 1;
                if (edge_count >= ratio)
                    lock_state = 1;
                if (counter <= 0)
                    out_state = (out_state == 0) ? 1 : 0;
            end
        end

        @(cross(V(clk_in) - vth, -1)) begin
            if (V(rst_n) < vth) begin
                out_state = 0;
            end else if (ratio == 1) begin
                out_state = 0;
                lock_state = 1;
            end
        end

        V(clk_out) <+ transition(out_state ? vhigh : vlow, 0, trf, trf);
        V(lock) <+ transition(lock_state ? vhigh : vlow, 0, trf, trf);
    end

endmodule
