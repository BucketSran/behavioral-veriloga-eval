`include "constants.vams"
`include "disciplines.vams"

module adpll_ratio_hop_ref (
    inout  electrical VDD,
    inout  electrical VSS,
    input  electrical ref_clk,
    input  electrical ratio_ctrl,
    output electrical fb_clk,
    output electrical vout,
    output electrical vctrl_mon,
    output electrical lock
);
    parameter real f_center = 240.0e6 from (0:inf);
    parameter real freq_step_hz = 5.0e6 from (0:inf);
    parameter real f_min = 120.0e6 from (0:inf);
    parameter real f_max = 420.0e6 from (0:inf);
    parameter integer code_min = 0 from [0:inf);
    parameter integer code_max = 63 from [1:inf);
    parameter integer code_center = 32 from [0:inf);
    parameter integer code_init = 24 from [0:inf);
    parameter integer ratio_min = 2 from [1:inf);
    parameter integer ratio_max = 16 from [2:inf);
    parameter real tedge = 200p from (0:inf);
    parameter real lock_tol = 2.0n from (0:inf);
    parameter integer lock_count_target = 5 from [1:inf);

    real vh;
    real vl;
    real vth;
    real ref_period_nom;
    real dco_freq;
    real dco_half_period;
    real t_next_dco;
    real ratio_sample;
    real ctrl_norm;

    integer ratio_cur;
    integer ratio_prev;
    integer dco_state;
    integer fb_state;
    integer fb_div_count;
    integer lock_state;
    integer settle_count;

    analog begin
        vh = V(VDD);
        vl = V(VSS);
        vth = 0.5 * (vh + vl);
        ref_period_nom = 20n;
        ratio_sample = V(ratio_ctrl);

        if (ratio_sample < 2.5) ratio_cur = 2;
        else if (ratio_sample < 3.5) ratio_cur = 3;
        else if (ratio_sample < 4.5) ratio_cur = 4;
        else if (ratio_sample < 5.5) ratio_cur = 5;
        else if (ratio_sample < 6.5) ratio_cur = 6;
        else if (ratio_sample < 7.5) ratio_cur = 7;
        else if (ratio_sample < 8.5) ratio_cur = 8;
        else if (ratio_sample < 9.5) ratio_cur = 9;
        else if (ratio_sample < 10.5) ratio_cur = 10;
        else if (ratio_sample < 11.5) ratio_cur = 11;
        else if (ratio_sample < 12.5) ratio_cur = 12;
        else if (ratio_sample < 13.5) ratio_cur = 13;
        else if (ratio_sample < 14.5) ratio_cur = 14;
        else if (ratio_sample < 15.5) ratio_cur = 15;
        else ratio_cur = 16;

        if (ratio_cur < ratio_min) ratio_cur = ratio_min;
        if (ratio_cur > ratio_max) ratio_cur = ratio_max;

        @(initial_step) begin
            ratio_prev = 4;
            dco_state = 0;
            fb_state = 0;
            fb_div_count = 0;
            lock_state = 0;
            settle_count = 0;
            dco_freq = 4.0 / ref_period_nom;
            dco_half_period = 0.5 / dco_freq;
            t_next_dco = $abstime + dco_half_period;
        end

        @(cross(V(ref_clk) - vth, +1)) begin
            if (ratio_cur != ratio_prev) begin
                ratio_prev = ratio_cur;
                fb_div_count = 0;
                settle_count = 0;
                lock_state = 0;
            end else begin
                settle_count = settle_count + 1;
                if (settle_count >= lock_count_target) begin
                    lock_state = 1;
                end
            end
        end

        @(timer(t_next_dco)) begin
            dco_state = 1 - dco_state;

            fb_div_count = fb_div_count + 1;
            if (fb_div_count >= ratio_cur) begin
                fb_div_count = 0;
                fb_state = 1 - fb_state;
            end

            // Graph relation: ratio_ctrl selects DCO cadence directly.
            dco_freq = ratio_cur / ref_period_nom;
            if (dco_freq < f_min) dco_freq = f_min;
            if (dco_freq > f_max) dco_freq = f_max;
            $bound_step(1.0 / (96.0 * dco_freq));
            dco_half_period = 0.5 / dco_freq;
            t_next_dco = t_next_dco + dco_half_period;
        end

        ctrl_norm = 1.0 * (ratio_cur - ratio_min) / (ratio_max - ratio_min);
        if (ctrl_norm < 0.0) ctrl_norm = 0.0;
        if (ctrl_norm > 1.0) ctrl_norm = 1.0;

        V(vout) <+ vl + (vh - vl) * transition(dco_state ? 1.0 : 0.0, 0.0, tedge, tedge);
        V(fb_clk) <+ vl + (vh - vl) * transition(fb_state ? 1.0 : 0.0, 0.0, tedge, tedge);
        V(vctrl_mon) <+ vl + (vh - vl) * ctrl_norm;
        V(lock) <+ vl + (vh - vl) * transition(lock_state ? 1.0 : 0.0, 0.0, tedge, tedge);
    end
endmodule
