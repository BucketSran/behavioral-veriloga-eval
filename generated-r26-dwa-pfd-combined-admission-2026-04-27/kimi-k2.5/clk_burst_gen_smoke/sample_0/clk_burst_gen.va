`include "constants.vams"
`include "disciplines.vams"

module clk_burst_gen (CLK, RST_N, CLK_OUT);
    input CLK;
    input RST_N;
    output CLK_OUT;
    electrical CLK, RST_N, CLK_OUT;

    parameter integer div = 8 from [3:inf);
    parameter real vhigh = 1.0;
    parameter real vlow = 0.0;
    parameter real vth = 0.5;
    parameter real tt = 1n;

    integer counter;
    integer burst_active;
    real out_val;

    analog begin
        @(initial_step) begin
            counter = 0;
            burst_active = 0;
            out_val = vlow;
        end

        // Detect rising edge of CLK - always at top level
        @(cross(V(CLK) - vth, 1)) begin
            if (V(RST_N) < vth) begin
                // Reset active - clear state
                counter = 0;
                burst_active = 0;
                out_val = vlow;
            end else begin
                // Normal operation
                if (counter < 2) begin
                    burst_active = 1;
                end else begin
                    burst_active = 0;
                end

                counter = counter + 1;
                if (counter >= div) begin
                    counter = 0;
                end
            end
        end

        // Detect falling edge of CLK - always at top level
        @(cross(V(CLK) - vth, -1)) begin
            if (V(RST_N) < vth) begin
                // Reset active - keep low
                burst_active = 0;
                out_val = vlow;
            end else begin
                // Normal operation - turn off output on falling edge
                burst_active = 0;
            end
        end

        // Continuous reset check for when reset is asserted asynchronously
        if (V(RST_N) < vth) begin
            out_val = vlow;
        end else begin
            // Set output based on burst_active state
            if (burst_active == 1) begin
                out_val = vhigh;
            end else begin
                out_val = vlow;
            end
        end

        V(CLK_OUT) <+ transition(out_val, 0, tt);
    end
endmodule
