`include "constants.vams"
`include "disciplines.vams"

module dac_ideal_4b (din_3, din_2, din_1, din_0, vdd, vss, rst_n, vout);
    input din_3, din_2, din_1, din_0, vdd, vss, rst_n;
    output vout;
    electrical din_3, din_2, din_1, din_0, vdd, vss, rst_n, vout;

    parameter real vth = 0.45 from (0:inf);
    parameter real tr = 10p from (0:inf);
    parameter real tf = 10p from (0:inf);
    parameter real td = 0 from [0:inf);

    integer code;
    real vout_val, vdd_val, vss_val;

    analog begin
        vdd_val = V(vdd);
        vss_val = V(vss);

        if (V(rst_n) < vth) begin
            code = 0;
        end else begin
            code = 0;
            if (V(din_3) > vth) code = code + 8;
            if (V(din_2) > vth) code = code + 4;
            if (V(din_1) > vth) code = code + 2;
            if (V(din_0) > vth) code = code + 1;
        end

        vout_val = vss_val + (code / 16.0) * (vdd_val - vss_val);
        V(vout) <+ transition(vout_val, td, tr, tf);
    end
endmodule
