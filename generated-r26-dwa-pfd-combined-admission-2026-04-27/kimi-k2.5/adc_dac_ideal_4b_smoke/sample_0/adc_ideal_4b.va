`include "constants.vams"
`include "disciplines.vams"

module adc_ideal_4b (vin, clk, vdd, vss, rst_n, dout_3, dout_2, dout_1, dout_0);
    input vin, clk, vdd, vss, rst_n;
    output dout_3, dout_2, dout_1, dout_0;
    electrical vin, clk, vdd, vss, rst_n, dout_3, dout_2, dout_1, dout_0;

    parameter real vth = 0.45 from (0:inf);
    parameter real tr = 10p from (0:inf);
    parameter real tf = 10p from (0:inf);
    parameter real td = 0 from [0:inf);

    integer code;
    real vstep, vdd_val, vss_val, vin_val;
    real vout_3, vout_2, vout_1, vout_0;
    real code_real;

    analog begin
        @(initial_step) begin
            code = 0;
        end

        vdd_val = V(vdd);
        vss_val = V(vss);
        vstep = (vdd_val - vss_val) / 16.0;

        @(cross(V(clk) - vth, 1)) begin
            if (V(rst_n) < vth) begin
                code = 0;
            end else begin
                vin_val = V(vin);
                if (vin_val <= vss_val) begin
                    code = 0;
                end else if (vin_val >= vdd_val) begin
                    code = 15;
                end else begin
                    code_real = floor((vin_val - vss_val) / vstep);
                    if (code_real > 15.0) code_real = 15.0;
                    if (code_real < 0.0) code_real = 0.0;
                    code = code_real;
                end
            end
        end

        vout_3 = (code >> 3) & 1;
        vout_2 = (code >> 2) & 1;
        vout_1 = (code >> 1) & 1;
        vout_0 = code & 1;

        V(dout_3) <+ transition(vout_3 * vdd_val, td, tr, tf);
        V(dout_2) <+ transition(vout_2 * vdd_val, td, tr, tf);
        V(dout_1) <+ transition(vout_1 * vdd_val, td, tr, tf);
        V(dout_0) <+ transition(vout_0 * vdd_val, td, tr, tf);
    end
endmodule
