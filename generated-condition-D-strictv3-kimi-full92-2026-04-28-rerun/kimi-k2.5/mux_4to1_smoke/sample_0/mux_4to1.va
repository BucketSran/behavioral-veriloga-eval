`include "constants.vams"
`include "disciplines.vams"

module mux_4to1 (vdd, vss, d3, d2, d1, d0, sel1, sel0, y);
    input vdd, vss, d3, d2, d1, d0, sel1, sel0;
    output y;
    electrical vdd, vss, d3, d2, d1, d0, sel1, sel0, y;

    parameter real vth = 0.45;
    parameter real tedge = 100p;

    real selected;
    integer sel;

    analog begin
        // Determine selection based on sel1, sel0
        if (V(sel1) > vth && V(sel0) > vth)
            sel = 3;
        else if (V(sel1) > vth && V(sel0) <= vth)
            sel = 2;
        else if (V(sel1) <= vth && V(sel0) > vth)
            sel = 1;
        else
            sel = 0;

        // Select appropriate input
        case (sel)
            0: selected = V(d0);
            1: selected = V(d1);
            2: selected = V(d2);
            3: selected = V(d3);
            default: selected = V(d0);
        endcase

        // Output with transition smoothing
        V(y) <+ transition(selected, 0, tedge);
    end
endmodule
