simulator lang=spectre
global 0

ahdl_include "lfsr.va"

// Power supplies
Vdd (vdd 0) vsource dc=1.8
Vss (vss 0) vsource dc=0

// Reset: active low, asserted at start, deasserts at 101ns
Vrstb (rstb 0) vsource type=pwl wave=[0 0 100n 0 101n 1.8]

// Enable: high throughout
Ven (en 0) vsource dc=1.8

// Clock: 1 GHz = 1ns period, 50% duty cycle
// Start after reset deassertion to ensure clean startup
Vclk (clk 0) vsource type=pulse val0=0 val1=1.8 period=1n rise=0.1n fall=0.1n width=0.4n delay=102n

// DUT instance
XDUT (dpn vdd vss clk en rstb) lfsr

// Transient analysis
tran tran stop=500n maxstep=2n

// Save statements for required observables
save dpn
save rstb
save clk
save en
