`include "constants.vams"
`include "disciplines.vams"

module gray_counter_one_bit_change_ref (vdd, vss, clk, rst, g0, g1, g2, g3);
    inout vdd, vss;
    input clk, rst;
    output g0, g1, g2, g3;
    electrical vdd, vss, clk, rst, g0, g1, g2, g3;

    parameter real vhi = 1.8;
    parameter real vlo = 0.0;
    parameter real vth = 0.9;
    parameter real tr = 1e-9;
    parameter real tf = 1e-9;

    integer bin_count;
    integer gray_code;
    integer g0_val, g1_val, g2_val, g3_val;

    analog begin
        @(initial_step) begin
            bin_count = 0;
            gray_code = 0;
            g0_val = 0;
            g1_val = 0;
            g2_val = 0;
            g3_val = 0;
        end

        @(cross(V(clk) - vth, 1)) begin
            if (V(rst) > vth) begin
                // Reset active (high)
                bin_count = 0;
            end else begin
                // Increment binary counter on rising edge when reset is low
                bin_count = bin_count + 1;
                if (bin_count > 15) begin
                    bin_count = 0;
                end
            end

            // Convert binary to Gray code: gray = bin ^ (bin >> 1)
            gray_code = bin_count ^ (bin_count >> 1);

            // Extract individual bits
            g0_val = gray_code & 1;
            g1_val = (gray_code >> 1) & 1;
            g2_val = (gray_code >> 2) & 1;
            g3_val = (gray_code >> 3) & 1;
        end

        // Drive outputs with transitions
        V(g0) <+ transition(g0_val * vhi, 0, tr, tf);
        V(g1) <+ transition(g1_val * vhi, 0, tr, tf);
        V(g2) <+ transition(g2_val * vhi, 0, tr, tf);
        V(g3) <+ transition(g3_val * vhi, 0, tr, tf);
    end
endmodule
