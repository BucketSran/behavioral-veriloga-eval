`include "constants.vams"
`include "disciplines.vams"

module vin_src (clk, rst_n, vinp, vinn);
    input clk;
    input rst_n;
    output vinp;
    output vinn;
    electrical clk, rst_n, vinp, vinn;

    parameter real vdd = 0.9;
    parameter real vss = 0.0;
    parameter real vcm = 0.45;
    parameter real vdiff_amp = 0.01;
    parameter real vth = 0.45;
    parameter real tr = 1n;
    parameter real tf = 1n;

    integer state;
    real vdiff;

    analog begin
        @(initial_step) begin
            state = 0;
        end

        @(cross(V(clk) - vth, 1)) begin
            if (V(rst_n) < vth) begin
                state = 0;
            end else begin
                state = state + 1;
            end
        end

        // Generate differential stimulus: alternating pattern
        if (state[0] == 0) begin
            vdiff = vdiff_amp;
        end else begin
            vdiff = -vdiff_amp;
        end

        V(vinp) <+ transition(vcm + vdiff/2.0, 0, tr, tf);
        V(vinn) <+ transition(vcm - vdiff/2.0, 0, tr, tf);
    end
endmodule
