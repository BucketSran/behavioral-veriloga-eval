simulator lang=spectre
global 0

ahdl_include "pfd_updn.va"

// Supply
Vvdd (vdd 0) vsource dc=0.9
Vvss (vss 0) vsource dc=0

// Reference clock: 100MHz, 50% duty
Vref (ref 0) vsource type=pulse val0=0 val1=0.9 period=10n rise=100p fall=100p width=5n

// Divided clock: same frequency, small phase offset (~2ps lead then lag)
// First 100ns: div leads ref by 2ps, then lags by 2ps
Vdiv (div 0) vsource type=pwl wave=[0n 0 \
                                    0.1n 0.9 \
                                    5n 0.9 \
                                    5.1n 0 \
                                    9.998n 0 \
                                    10.098n 0.9 \
                                    15n 0.9 \
                                    15.1n 0 \
                                    19.998n 0 \
                                    20.098n 0.9 \
                                    25n 0.9 \
                                    25.1n 0 \
                                    29.998n 0 \
                                    30.098n 0.9 \
                                    35n 0.9 \
                                    35.1n 0 \
                                    39.998n 0 \
                                    40.098n 0.9 \
                                    45n 0.9 \
                                    45.1n 0 \
                                    49.998n 0 \
                                    50.098n 0.9 \
                                    55n 0.9 \
                                    55.1n 0 \
                                    59.998n 0 \
                                    60.098n 0.9 \
                                    65n 0.9 \
                                    65.1n 0 \
                                    69.998n 0 \
                                    70.098n 0.9 \
                                    75n 0.9 \
                                    75.1n 0 \
                                    79.998n 0 \
                                    80.098n 0.9 \
                                    85n 0.9 \
                                    85.1n 0 \
                                    89.998n 0 \
                                    90.098n 0.9 \
                                    95n 0.9 \
                                    95.1n 0 \
                                    99.998n 0 \
                                    100.098n 0.9 \
                                    105n 0.9 \
                                    105.1n 0 \
                                    109.998n 0 \
                                    110.098n 0.9 \
                                    115n 0.9 \
                                    115.1n 0 \
                                    119.998n 0 \
                                    120.098n 0.9 \
                                    125n 0.9 \
                                    125.1n 0 \
                                    129.998n 0 \
                                    130.098n 0.9 \
                                    135n 0.9 \
                                    135.1n 0 \
                                    139.998n 0 \
                                    140.098n 0.9 \
                                    145n 0.9 \
                                    145.1n 0 \
                                    149.998n 0 \
                                    150.098n 0.9 \
                                    155n 0.9 \
                                    155.1n 0 \
                                    159.998n 0 \
                                    160.098n 0.9 \
                                    165n 0.9 \
                                    165.1n 0 \
                                    169.998n 0 \
                                    170.098n 0.9 \
                                    175n 0.9 \
                                    175.1n 0 \
                                    179.998n 0 \
                                    180.098n 0.9 \
                                    185n 0.9 \
                                    185.1n 0 \
                                    189.998n 0 \
                                    190.098n 0.9 \
                                    195n 0.9 \
                                    195.1n 0 \
                                    199.998n 0 \
                                    200.098n 0.9 \
                                    205n 0.9 \
                                    205.1n 0 \
                                    209.998n 0 \
                                    210.098n 0.9 \
                                    215n 0.9 \
                                    215.1n 0 \
                                    219.998n 0 \
                                    220.098n 0.9 \
                                    225n 0.9 \
                                    225.1n 0 \
                                    229.998n 0 \
                                    230.098n 0.9 \
                                    235n 0.9 \
                                    235.1n 0 \
                                    239.998n 0 \
                                    240.098n 0.9 \
                                    245n 0.9 \
                                    245.1n 0 \
                                    249.998n 0 \
                                    250.098n 0.9 \
                                    255n 0.9 \
                                    255.1n 0 \
                                    259.998n 0 \
                                    260.098n 0.9 \
                                    265n 0.9 \
                                    265.1n 0 \
                                    269.998n 0 \
                                    270.098n 0.9 \
                                    275n 0.9 \
                                    275.1n 0 \
                                    279.998n 0 \
                                    280.098n 0.9 \
                                    285n 0.9 \
                                    285.1n 0 \
                                    289.998n 0 \
                                    290.098n 0.9 \
                                    295n 0.9 \
                                    295.1n 0 \
                                    299.998n 0 \
                                    300.098n 0.9]

// DUT
XDUT (vdd vss ref div up dn) pfd_updn

// Save outputs
save ref div up dn

// Transient analysis
tran tran stop=300n maxstep=5p errpreset=conservative
