`include "constants.vams"
`include "disciplines.vams"

module multitone (OUT);
    output OUT;
    electrical OUT;

    parameter integer N = 4 from [1:8];
    parameter real freq[0:7] = '{1e6, 2e6, 3e6, 4e6, 0, 0, 0, 0};
    parameter real amp[0:7] = '{1.0, 0.5, 0.25, 0.125, 0, 0, 0, 0};

    real max_freq;
    real out_val;
    integer i;

    analog begin
        @(initial_step) begin
            max_freq = 0.0;
            for (i = 0; i < N; i = i + 1) begin
                if (freq[i] > max_freq) begin
                    max_freq = freq[i];
                end
            end
        end

        $bound_step(0.1 / max_freq);

        out_val = 0.0;
        for (i = 0; i < N; i = i + 1) begin
            out_val = out_val + amp[i] * sin(2.0 * `M_PI * freq[i] * $abstime);
        end

        V(OUT) <+ out_val;
    end
endmodule
