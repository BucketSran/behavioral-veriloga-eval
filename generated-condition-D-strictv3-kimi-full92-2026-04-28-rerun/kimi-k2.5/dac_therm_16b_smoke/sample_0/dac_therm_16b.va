`include "constants.vams"
`include "disciplines.vams"

module dac_therm_16b (din_therm, rst_n, vout);
    input [15:0] din_therm;
    input rst_n;
    output vout;
    electrical [15:0] din_therm;
    electrical rst_n;
    electrical vout;

    parameter real vstep = 1.0 from [0:inf);
    parameter real tr = 1n from (0:inf);
    parameter real tf = 1n from (0:inf);

    integer i;
    integer count;
    real vout_val;

    analog begin
        @(initial_step) begin
            count = 0;
            vout_val = 0.0;
        end

        // Count ones in thermometer code
        count = 0;
        for (i = 0; i < 16; i = i + 1) begin
            if (V(din_therm[i]) > 0.5) begin
                count = count + 1;
            end
        end

        // Calculate output voltage based on reset and count
        if (V(rst_n) < 0.5) begin
            vout_val = 0.0;
        end else begin
            vout_val = count * vstep;
        end

        // Drive output with transition
        V(vout) <+ transition(vout_val, 0, tr, tf);
    end
endmodule
