`include "constants.vams"
`include "disciplines.vams"

module ramp_gen (clk_in, rst_n, code_3, code_2, code_1, code_0);
    input clk_in;
    input rst_n;
    output code_3;
    output code_2;
    output code_1;
    output code_0;
    electrical clk_in, rst_n, code_3, code_2, code_1, code_0;

    parameter real vhigh = 1.8;
    parameter real vlow = 0.0;
    parameter real vth = 0.9;
    parameter real tr = 1n;
    parameter real tf = 1n;

    integer code;
    real vout_3, vout_2, vout_1, vout_0;

    analog begin
        @(initial_step) begin
            code = 0;
        end

        @(cross(V(rst_n) - vth, -1)) begin
            code = 0;
        end

        @(cross(V(clk_in) - vth, 1)) begin
            if (V(rst_n) > vth) begin
                if (code < 15) begin
                    code = code + 1;
                end
            end
        end

        vout_3 = (code >= 8) ? vhigh : vlow;
        vout_2 = ((code >= 4) && (code < 8)) || (code >= 12) ? vhigh : vlow;
        vout_1 = ((code >= 2) && (code < 4)) || ((code >= 6) && (code < 8)) || ((code >= 10) && (code < 12)) || (code >= 14) ? vhigh : vlow;
        vout_0 = (code % 2 == 1) ? vhigh : vlow;

        V(code_3) <+ transition(vout_3, 0, tr, tf);
        V(code_2) <+ transition(vout_2, 0, tr, tf);
        V(code_1) <+ transition(vout_1, 0, tr, tf);
        V(code_0) <+ transition(vout_0, 0, tr, tf);
    end
endmodule
