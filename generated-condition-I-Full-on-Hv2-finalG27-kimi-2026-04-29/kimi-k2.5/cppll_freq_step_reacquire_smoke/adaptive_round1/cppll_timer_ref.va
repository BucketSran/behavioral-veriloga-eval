`include "constants.vams"
`include "disciplines.vams"

module cppll_timer_ref (VDD, VSS, ref_clk, fb_clk, dco_clk, vctrl_mon, lock);
    input VDD, VSS, ref_clk;
    output fb_clk, dco_clk, vctrl_mon, lock;
    inout VDD, VSS;
    electrical VDD, VSS, ref_clk, fb_clk, dco_clk, vctrl_mon, lock;

    parameter real vhi = 1.8;
    parameter real vlo = 0.0;
    parameter real vth = 0.9;
    parameter real trf = 0.1n;
    parameter real tdel = 0.0;
    parameter real kp = 2e-3;
    parameter real ki = 1e-4;
    parameter real f0 = 400e6;
    parameter real kvco = 200e6;
    parameter integer ndiv = 8;
    parameter real lock_thr = 0.1;
    parameter integer lock_cnt_max = 30;

    real vctrl;
    real fosc;
    real tref, tref_prev, tref_delta;
    real tfb, tfb_prev, tfb_delta;
    real terr, terr_int;
    real tnext_dco;
    integer dco_state;
    integer fb_state;
    integer ref_edge_cnt;
    integer fb_edge_cnt;
    integer lock_cnt;
    integer locked;
    integer div_cnt;
    integer initialized;

    analog begin
        @(initial_step) begin
            vctrl = vhi / 2.0;
            fosc = f0;
            tnext_dco = 0.0;
            dco_state = 0;
            fb_state = 0;
            ref_edge_cnt = 0;
            fb_edge_cnt = 0;
            tref_prev = 0.0;
            tfb_prev = 0.0;
            tref_delta = 20n;
            tfb_delta = 20n;
            terr = 0.0;
            terr_int = 0.0;
            lock_cnt = 0;
            locked = 0;
            div_cnt = 0;
            initialized = 0;
        end

        @(cross(V(ref_clk) - vth, 1)) begin
            tref = $abstime;
            tref_delta = tref - tref_prev;
            tref_prev = tref;
            ref_edge_cnt = ref_edge_cnt + 1;

            if (initialized) begin
                terr = tref_delta - tfb_delta;
                terr_int = terr_int + terr * ki;
                if (terr_int > vhi/2.0) terr_int = vhi/2.0;
                if (terr_int < -vhi/2.0) terr_int = -vhi/2.0;
                vctrl = vhi/2.0 + kp * terr + terr_int;
                if (vctrl > vhi) vctrl = vhi;
                if (vctrl < vlo) vctrl = vlo;
                fosc = f0 + kvco * (vctrl - vhi/2.0) / vhi;
                if (fosc < f0/4.0) fosc = f0/4.0;
                if (fosc > 4.0*f0) fosc = 4.0*f0;
            end
        end

        @(timer(tnext_dco)) begin
            dco_state = !dco_state;
            tnext_dco = $abstime + 0.5/fosc;

            div_cnt = div_cnt + 1;
            if (div_cnt >= ndiv) begin
                div_cnt = 0;
                fb_state = !fb_state;
                fb_edge_cnt = fb_edge_cnt + 1;
                tfb = $abstime;
                tfb_delta = tfb - tfb_prev;
                tfb_prev = tfb;

                if (!initialized && fb_edge_cnt > 2) begin
                    initialized = 1;
                end

                if (initialized && ref_edge_cnt > ndiv && fb_edge_cnt > ndiv) begin
                    if (abs(terr) < lock_thr * tref_delta) begin
                        lock_cnt = lock_cnt + 1;
                        if (lock_cnt >= lock_cnt_max) locked = 1;
                    end else begin
                        lock_cnt = 0;
                        locked = 0;
                    end
                end
            end
        end

        V(dco_clk) <+ transition(dco_state ? vhi : vlo, tdel, trf);
        V(fb_clk) <+ transition(fb_state ? vhi : vlo, tdel, trf);
        V(vctrl_mon) <+ transition(vctrl, tdel, trf);
        V(lock) <+ transition(locked ? vhi : vlo, tdel, trf);
    end
endmodule
