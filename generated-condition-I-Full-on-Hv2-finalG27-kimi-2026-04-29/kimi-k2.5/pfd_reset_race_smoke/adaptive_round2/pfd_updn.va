`include "constants.vams"
`include "disciplines.vams"

module pfd_updn (VDD, VSS, REF, DIV, UP, DN);
    inout VDD, VSS;
    input REF, DIV;
    output UP, DN;
    electrical VDD, VSS, REF, DIV, UP, DN;

    parameter real vth = 0.5 from (0:inf);
    parameter real tr = 100p from (0:inf);
    parameter real tf = 100p from (0:inf);
    parameter real td = 0 from [0:inf);
    parameter real pulse_width = 5n from (0:inf);

    integer up_state, dn_state;
    real up_release_time, dn_release_time;
    real vhi, vlo;

    analog begin
        @(initial_step) begin
            up_state = 0;
            dn_state = 0;
            up_release_time = 0;
            dn_release_time = 0;
        end

        // Detect rising edge of REF
        @(cross(V(REF) - vth, 1)) begin
            if (dn_state == 0) begin
                // REF leads: set UP, schedule release
                up_state = 1;
                up_release_time = $abstime + pulse_width;
            end
            else begin
                // REF arrives while DN is high: reset both (race condition)
                up_state = 0;
                dn_state = 0;
                up_release_time = 0;
                dn_release_time = 0;
            end
        end

        // Detect rising edge of DIV
        @(cross(V(DIV) - vth, 1)) begin
            if (up_state == 0) begin
                // DIV leads: set DN, schedule release
                dn_state = 1;
                dn_release_time = $abstime + pulse_width;
            end
            else begin
                // DIV arrives while UP is high: reset both (race condition)
                up_state = 0;
                dn_state = 0;
                up_release_time = 0;
                dn_release_time = 0;
            end
        end

        // Release UP pulse after pulse_width
        if (up_state == 1 && $abstime >= up_release_time) begin
            up_state = 0;
            up_release_time = 0;
        end

        // Release DN pulse after pulse_width
        if (dn_state == 1 && $abstime >= dn_release_time) begin
            dn_state = 0;
            dn_release_time = 0;
        end

        // Output voltage levels based on VDD/VSS
        vhi = V(VDD);
        vlo = V(VSS);

        // Drive outputs with transition
        V(UP) <+ transition(up_state ? vhi : vlo, td, tr, tf);
        V(DN) <+ transition(dn_state ? vhi : vlo, td, tr, tf);
    end
endmodule
