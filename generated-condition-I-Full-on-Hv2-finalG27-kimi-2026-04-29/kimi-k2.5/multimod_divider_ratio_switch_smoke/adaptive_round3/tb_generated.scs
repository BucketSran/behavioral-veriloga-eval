simulator lang=spectre
global 0

ahdl_include "multimod_divider_ratio_switch_ref.va"

// Clock input: 100MHz (10ns period) with 50% duty cycle
Vclk (clk_in 0) vsource type=pulse val0=0 val1=1.8 period=10n rise=100p fall=100p width=5n

// Ratio control: starts low (divide-by-4), switches high at 150ns (divide-by-5)
// Changed to switch at 100ns to allow more time for div5 window
Vctrl (ratio_ctrl 0) vsource type=pwl wave=[0n 0 100n 0 110n 1.8 320n 1.8]

// DUT instance
XDUT (clk_in ratio_ctrl div_out) multimod_divider_ratio_switch_ref

// Transient analysis
tran tran stop=320n maxstep=20p errpreset=conservative

// Save required signals
save clk_in div_out ratio_ctrl
