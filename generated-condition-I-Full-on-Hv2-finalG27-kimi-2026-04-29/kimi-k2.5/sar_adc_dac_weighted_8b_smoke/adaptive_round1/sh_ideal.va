`include "constants.vams"
`include "disciplines.vams"

module sh_ideal (vin, clks, vdd, vss, rst_n, vin_sh);
    input vin;
    input clks;
    input vdd;
    input vss;
    input rst_n;
    output vin_sh;
    electrical vin;
    electrical clks;
    electrical vdd;
    electrical vss;
    electrical rst_n;
    electrical vin_sh;

    parameter real vth = 0.45 from (0:inf);
    parameter real tdel = 0 from [0:inf);
    parameter real tr = 1n from (0:inf);
    parameter real tf = 1n from (0:inf);

    real sampled;
    integer rst_active;

    analog begin
        @(initial_step) begin
            sampled = 0.0;
            rst_active = 1;
        end

        @(cross(V(rst_n) - vth, -1)) begin
            rst_active = 0;
        end

        @(cross(V(rst_n) - vth, +1)) begin
            rst_active = 1;
            sampled = 0.0;
        end

        @(cross(V(clks) - vth, +1)) begin
            if (rst_active == 0) begin
                sampled = V(vin);
            end
        end

        V(vin_sh) <+ transition(sampled, tdel, tr, tf);
    end
endmodule
