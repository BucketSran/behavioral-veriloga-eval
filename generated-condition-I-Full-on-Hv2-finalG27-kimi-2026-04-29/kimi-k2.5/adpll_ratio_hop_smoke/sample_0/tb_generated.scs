simulator lang=spectre
global 0

ahdl_include "adpll_ratio_hop_ref.va"

// Supply
Vdd (vdd 0) vsource dc=1.8
Vss (vss 0) vsource dc=0

// Reference clock: 100MHz (10ns period)
Vref (ref_clk 0) vsource type=pulse val0=0 val1=1.8 period=10n rise=0.1n fall=0.1n width=5n

// Ratio control: step from 4V to 6V at 2.5us
Vratio (ratio_ctrl 0) vsource type=pwl wave=[0 4.0 2.5u 4.0 2.501u 6.0 5u 6.0]

// DUT
XDUT (vdd vss ref_clk ratio_ctrl fb_clk vout vctrl_mon lock) adpll_ratio_hop_ref

// Transient analysis
tran tran stop=5u maxstep=5n

// Save outputs
save ref_clk vout lock vctrl_mon ratio_ctrl
