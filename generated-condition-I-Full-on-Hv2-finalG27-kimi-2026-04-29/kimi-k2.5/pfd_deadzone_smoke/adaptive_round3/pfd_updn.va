`include "constants.vams"
`include "disciplines.vams"

module pfd_updn (vdd, vss, ref, div, up, dn);
    inout vdd, vss;
    input ref, div;
    output up, dn;
    electrical vdd, vss, ref, div, up, dn;

    parameter real vth = 0.45;
    parameter real tedge = 20p;

    integer up_state;
    integer dn_state;
    real vhi;
    real vlo;
    real up_timer;
    real dn_timer;
    real pulse_width;

    analog begin
        @(initial_step) begin
            up_state = 0;
            dn_state = 0;
            up_timer = 0;
            dn_timer = 0;
            pulse_width = 500p;
        end

        // Capture rising edge of ref: set up high, start timer
        @(cross(V(ref) - vth, 1)) begin
            up_state = 1;
            up_timer = $abstime;
        end

        // Capture rising edge of div: set dn high, start timer
        @(cross(V(div) - vth, 1)) begin
            dn_state = 1;
            dn_timer = $abstime;
        end

        // Auto-clear up after pulse_width
        if ((up_state == 1) && (($abstime - up_timer) >= pulse_width)) begin
            up_state = 0;
        end

        // Auto-clear dn after pulse_width
        if ((dn_state == 1) && (($abstime - dn_timer) >= pulse_width)) begin
            dn_state = 0;
        end

        // Reset when both are high (both edges arrived close together)
        if ((up_state == 1) && (dn_state == 1)) begin
            up_state = 0;
            dn_state = 0;
        end

        // Read supply levels dynamically
        vhi = V(vdd);
        vlo = V(vss);

        // Drive outputs with transition for finite edge times
        V(up) <+ transition(up_state ? vhi : vlo, 0, tedge);
        V(dn) <+ transition(dn_state ? vhi : vlo, 0, tedge);
    end
endmodule
