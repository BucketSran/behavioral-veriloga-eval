simulator lang=spectre
global 0

ahdl_include "cross_hysteresis_window_ref.va"

// Power supply
VDD (VDD 0) vsource dc=1.0
VSS (VSS 0) vsource dc=0.0

// Input stimulus: ramp up past 0.6V, then ramp down below 0.3V
Vin (vin 0) vsource type=pwl wave=[0n 0.0 20n 0.0 50n 0.8 70n 0.8 90n 0.0]

// DUT instance
XDUT (vin out VDD VSS) cross_hysteresis_window_ref

// Transient analysis
tran tran stop=90n maxstep=20p errpreset=conservative

// Save signals for evaluation
save vin out
