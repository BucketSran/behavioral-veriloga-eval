`include "constants.vams"
`include "disciplines.vams"

module adpll_timer_ref (VDD, VSS, ref_clk, fb_clk, dco_clk, vctrl_mon, lock);
    inout VDD, VSS;
    input ref_clk;
    output fb_clk, dco_clk, vctrl_mon, lock;
    electrical VDD, VSS, ref_clk, fb_clk, dco_clk, vctrl_mon, lock;

    // Parameters
    parameter real vhi = 1.8 from (0:inf);
    parameter real vlo = 0.0 from [0:inf);
    parameter real vth = 0.9 from (0:inf);
    parameter real tdel = 1p from [0:inf);
    parameter real tr = 100p from (0:inf);
    parameter real tf = 100p from (0:inf);
    parameter real ref_freq = 50e6 from (0:inf);
    parameter real dco_center_freq = 800e6 from (0:inf);
    parameter integer div_ratio = 8 from [1:inf);
    parameter real kp = 0.01 from (0:inf);
    parameter real lock_threshold = 0.05 from (0:inf);
    parameter integer lock_count = 50 from [1:inf);

    // State variables
    integer dco_code;
    integer div_cnt;
    integer fb_val;
    integer dco_val;
    integer lock_val;
    integer ref_edge_cnt;
    integer fb_edge_cnt;
    integer lock_cnt;
    integer phase_err;
    integer prev_ref;
    integer prev_fb;
    integer ref_rising;
    integer fb_rising;
    integer lock_detect;
    integer ref_detected;
    integer fb_detected;

    // Internal variables
    real vctrl_norm;
    real dco_period_real;
    real ref_time;
    real fb_time;
    real last_ref_time;
    real last_fb_time;
    real t_next;
    real period_err;
    real ref_period;
    real fb_period;

    analog begin
        @(initial_step) begin
            dco_code = 512;
            div_cnt = 0;
            fb_val = 0;
            dco_val = 0;
            lock_val = 0;
            ref_edge_cnt = 0;
            fb_edge_cnt = 0;
            lock_cnt = 0;
            phase_err = 0;
            prev_ref = 0;
            prev_fb = 0;
            ref_rising = 0;
            fb_rising = 0;
            lock_detect = 0;
            ref_detected = 0;
            fb_detected = 0;
            ref_time = 0;
            fb_time = 0;
            last_ref_time = 0;
            last_fb_time = 0;
            t_next = 1.25e-9;
            period_err = 0;
            ref_period = 20e-9;
            fb_period = 20e-9;
        end

        // Detect reference clock edges
        @(cross(V(ref_clk) - vth, 1)) begin
            ref_rising = 1;
            ref_edge_cnt = ref_edge_cnt + 1;
            last_ref_time = ref_time;
            ref_time = $abstime;
            if (last_ref_time > 0) begin
                ref_period = ref_time - last_ref_time;
            end
            ref_detected = 1;
        end

        // Detect feedback clock edges
        @(cross(V(fb_clk) - vth, 1)) begin
            fb_rising = 1;
            fb_edge_cnt = fb_edge_cnt + 1;
            last_fb_time = fb_time;
            fb_time = $abstime;
            if (last_fb_time > 0) begin
                fb_period = fb_time - last_fb_time;
            end
            fb_detected = 1;
        end

        // Bang-bang phase/frequency detector with period comparison
        if (ref_rising) begin
            // Compare periods for frequency detection
            if (ref_period > 0 && fb_period > 0) begin
                period_err = ref_period - fb_period;
                if (period_err > 0.5e-9) begin
                    // Reference period longer, FB too fast, decrease DCO
                    if (dco_code > 0) begin
                        dco_code = dco_code - 1;
                    end
                    phase_err = -1;
                end else if (period_err < -0.5e-9) begin
                    // Reference period shorter, FB too slow, increase DCO
                    if (dco_code < 1023) begin
                        dco_code = dco_code + 1;
                    end
                    phase_err = 1;
                end else begin
                    // Periods matched
                    phase_err = 0;
                end
            end else begin
                // No valid period yet, use phase comparison
                if (!fb_detected || (ref_time > fb_time + 1e-9)) begin
                    if (dco_code < 1023) begin
                        dco_code = dco_code + 1;
                    end
                    phase_err = 1;
                end else if (fb_time > ref_time + 1e-9) begin
                    if (dco_code > 0) begin
                        dco_code = dco_code - 1;
                    end
                    phase_err = -1;
                end else begin
                    phase_err = 0;
                end
            end
            ref_rising = 0;
        end

        if (fb_rising) begin
            fb_rising = 0;
        end

        // Calculate DCO period based on control code
        // Target: when dco_code = 512, DCO runs at 800 MHz
        // With div_ratio=8, fb_clk = 800M/8 = 100 MHz initially
        // Code adjustment brings it to 50 MHz
        dco_period_real = 1.0 / (dco_center_freq * (0.5 + 1.0 * dco_code / 1023.0));

        // DCO using timer - schedule next edge
        @(timer(t_next)) begin
            dco_val = !dco_val;
            t_next = $abstime + dco_period_real / 2.0;

            // Divider for feedback clock - count on DCO edges
            div_cnt = div_cnt + 1;
            if (div_cnt >= div_ratio) begin
                div_cnt = 0;
                fb_val = !fb_val;
            end
        end

        // Lock detection based on period stability
        if (ref_detected && fb_detected) begin
            if (ref_period > 0 && fb_period > 0) begin
                period_err = ref_period - fb_period;
                if ((period_err > -1e-9) && (period_err < 1e-9)) begin
                    lock_cnt = lock_cnt + 1;
                end else begin
                    lock_cnt = 0;
                end

                if (lock_cnt >= lock_count) begin
                    lock_detect = 1;
                end
            end
        end

        // Drive outputs with transitions
        V(dco_clk) <+ transition(dco_val ? vhi : vlo, tdel, tr, tf);
        V(fb_clk) <+ transition(fb_val ? vhi : vlo, tdel, tr, tf);
        V(lock) <+ transition(lock_detect ? vhi : vlo, tdel, tr, tf);

        // vctrl_mon: normalized control voltage (0 to vhi)
        vctrl_norm = vhi * dco_code / 1023.0;
        V(vctrl_mon) <+ transition(vctrl_norm, tdel, tr, tf);
    end
endmodule
