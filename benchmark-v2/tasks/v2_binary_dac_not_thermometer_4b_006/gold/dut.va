`include "constants.vams"
`include "disciplines.vams"

module v2_binary_dac_not_thermometer_4b_006(scale0, scale1, scale2, scale3, vdd, vss, analog_sum);
    input scale0, scale1, scale2, scale3, vdd, vss;
    output analog_sum;
    electrical scale0, scale1, scale2, scale3, vdd, vss, analog_sum;
    parameter real vth = 0.45;
    parameter real tr = 40p;
    integer code_q;
    real out_t;

    analog begin
        code_q = 0;
        if (V(scale0) >= vth) code_q = code_q + 1;
        if (V(scale1) >= vth) code_q = code_q + 2;
        if (V(scale2) >= vth) code_q = code_q + 4;
        if (V(scale3) >= vth) code_q = code_q + 8;
        out_t = V(vss) + (V(vdd) - V(vss)) * code_q / 15.0;
        V(analog_sum) <+ transition(out_t, 0.0, tr, tr);
    end
endmodule
