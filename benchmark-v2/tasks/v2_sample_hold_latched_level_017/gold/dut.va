`include "constants.vams"
`include "disciplines.vams"

module v2_sample_hold_latched_level_017(external_drive, capture_tick, vdd, vss, held_sample);
    input external_drive, capture_tick, vdd, vss;
    output held_sample;
    electrical external_drive, capture_tick, vdd, vss, held_sample;
    parameter real vth = 0.45;
    parameter real tr = 50p;
    real held_v;

    analog begin
        @(initial_step) begin
            held_v = V(vss);
        end

        @(cross(V(capture_tick) - vth, +1)) begin
            held_v = V(external_drive);
        end

        V(held_sample) <+ transition(held_v, 0.0, tr, tr);
    end
endmodule
