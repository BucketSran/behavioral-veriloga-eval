`include "constants.vams"
`include "disciplines.vams"

module v2_ext_threshold_detector_004(sensor_reading, vdd, vss, trip_flag);
    input sensor_reading, vdd, vss;
    output trip_flag;
    electrical sensor_reading, vdd, vss, trip_flag;
    parameter real threshold = 0.45;
    parameter real tr = 40p;
    real out_t;

    analog begin
        out_t = (V(sensor_reading) >= threshold) ? V(vdd) : V(vss);
        V(trip_flag) <+ transition(out_t, 0.0, tr, tr);
    end
endmodule
