simulator lang=spectre
global 0

ahdl_include "dut.va"

Vvdd (vdd 0) vsource dc=0.9
Vvss (vss 0) vsource dc=0
Vclk (strobe 0) vsource type=pulse val0=0 val1=0.9 delay=0 rise=50p fall=50p width=0.9n period=2n
Vrst (clear_n 0) vsource type=pwl wave=[ 0 0 3n 0 3.1n 0.9 90n 0.9 ]
Vvin (analog_sample 0) vsource type=pwl wave=[ 0 0 90n 0.9 ]

XDUT (analog_sample strobe clear_n vdd vss level5 level4 level3 level2 level1 level0 latched_level) v2_adc_dac_alias_sampled_code_6b_019

tran tran stop=120n maxstep=500p
save analog_sample strobe clear_n latched_level level0 level1 level2 level3 level4 level5
