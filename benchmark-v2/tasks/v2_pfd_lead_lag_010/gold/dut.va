`include "constants.vams"
`include "disciplines.vams"

module v2_pfd_lead_lag_010(early_event, late_event, vdd, vss, advance_pulse, retard_pulse, locked);
    input early_event, late_event, vdd, vss;
    output advance_pulse, retard_pulse, locked;
    electrical early_event, late_event, vdd, vss, advance_pulse, retard_pulse, locked;
    parameter real vth = 0.45;
    parameter real pulse_width = 1.0n;
    parameter real tr = 40p;
    integer up_q;
    integer dn_q;
    real up_clear_t;
    real dn_clear_t;
    integer stable_count;
    real lock_t;

    analog begin
        @(initial_step) begin
            up_q = 0;
            dn_q = 0;
            up_clear_t = 1.0;
            dn_clear_t = 1.0;
            stable_count = 0;
            lock_t = V(vss);
        end

        @(cross(V(early_event) - vth, +1)) begin
            up_q = 1;
            dn_q = 0;
            up_clear_t = $abstime + pulse_width;
            stable_count = stable_count + 1;
            if (stable_count > 5) lock_t = V(vdd);
        end

        @(cross(V(late_event) - vth, +1)) begin
            dn_q = 1;
            up_q = 0;
            dn_clear_t = $abstime + pulse_width;
        end

        @(timer(up_clear_t)) begin
            up_q = 0;
            up_clear_t = 1.0;
        end

        @(timer(dn_clear_t)) begin
            dn_q = 0;
            dn_clear_t = 1.0;
        end

        V(advance_pulse) <+ transition(up_q ? V(vdd) : V(vss), 0.0, tr, tr);
        V(retard_pulse) <+ transition(dn_q ? V(vdd) : V(vss), 0.0, tr, tr);
        V(locked) <+ transition(lock_t, 0.0, tr, tr);
    end
endmodule
