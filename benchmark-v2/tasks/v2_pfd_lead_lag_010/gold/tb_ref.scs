simulator lang=spectre
global 0

ahdl_include "dut.va"

Vvdd (vdd 0) vsource dc=0.9
Vvss (vss 0) vsource dc=0
Vref (early_event 0) vsource type=pulse val0=0 val1=0.9 delay=1n rise=50p fall=50p width=4n period=10n
Vdiv (late_event 0) vsource type=pulse val0=0 val1=0.9 delay=4n rise=50p fall=50p width=4n period=10n

XDUT (early_event late_event vdd vss advance_pulse retard_pulse locked) v2_pfd_lead_lag_010

tran tran stop=120n maxstep=500p
save early_event late_event advance_pulse retard_pulse locked
