`include "constants.vams"
`include "disciplines.vams"

module v2_sample_hold_latched_level_010(sense_level, cadence, vdd, vss, capture_level);
    input sense_level, cadence, vdd, vss;
    output capture_level;
    electrical sense_level, cadence, vdd, vss, capture_level;
    parameter real vth = 0.45;
    parameter real tr = 50p;
    real held_v;

    analog begin
        @(initial_step) begin
            held_v = V(vss);
        end

        @(cross(V(cadence) - vth, +1)) begin
            held_v = V(sense_level);
        end

        V(capture_level) <+ transition(held_v, 0.0, tr, tr);
    end
endmodule
