`include "constants.vams"
`include "disciplines.vams"
`define N_lfsr 31
`default_transition 10p
module pseudo_random_source(
    output electrical PRBS_OUT, inout electrical SUPPLY_HI, inout electrical SUPPLY_LO,
    input electrical ADVANCE, input electrical RUN, input electrical INIT_N
);
parameter integer seed = 123;
real vtrans_advance; integer lfsr_r[`N_lfsr:0]; integer tmp_lfsr_r[(`N_lfsr+1):0]; integer i; real prbs_out_level;
analog begin
    @(initial_step or cross(V(INIT_N) - 0.5, -1)) begin
        vtrans_advance = 0.5;
        for (i = 0; i <= `N_lfsr; i = i + 1) lfsr_r[i] = (seed >> i) & 1;
        for (i = 0; i <= `N_lfsr; i = i + 5) lfsr_r[i] = 1;
        prbs_out_level = lfsr_r[`N_lfsr] > 0 ? V(SUPPLY_HI) : V(SUPPLY_LO);
    end
    @(cross(V(ADVANCE) - 0.5, +1)) begin
        if (V(INIT_N) > 0.5) begin
            for (i = 0; i <= `N_lfsr; i = i + 1) tmp_lfsr_r[i+1] = lfsr_r[i];
            tmp_lfsr_r[0] = lfsr_r[31] ^ lfsr_r[21] ^ lfsr_r[1] ^ lfsr_r[0];
            for (i = 0; i <= `N_lfsr; i = i + 1) lfsr_r[i] = tmp_lfsr_r[i];
            prbs_out_level = lfsr_r[`N_lfsr] > 0 ? V(SUPPLY_HI) : V(SUPPLY_LO);
        end
    end
    V(PRBS_OUT) <+ transition(prbs_out_level, 0, 50p, 50p);
end
endmodule
