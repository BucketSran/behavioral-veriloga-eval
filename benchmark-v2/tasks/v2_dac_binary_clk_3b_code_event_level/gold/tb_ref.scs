simulator lang=spectre
global 0

parameters vdd=1.2 period=20n
ahdl_include "dut.va"

Vclk (code_event 0) vsource type=pulse val0=0 val1=vdd delay=5n rise=100p fall=100p width=8n period=period
Vc0 (c0 0) vsource type=pwl wave=[0 0  19n 0  21n vdd  39n vdd  41n 0]
Vc1 (c1 0) vsource type=pwl wave=[0 0  39n 0  41n vdd  79n vdd  81n 0]
Vc2 (c2 0) vsource type=pwl wave=[0 0  79n 0  81n vdd]

Xdut (code_event c0 c1 c2 out_level) dac_binary_clk_3b_code_event_level

simulatorOptions options reltol=1e-4 vabstol=1e-6 iabstol=1e-12 temp=27 tnom=27
tran tran stop=110n maxstep=100p
saveOptions options save=allpub
