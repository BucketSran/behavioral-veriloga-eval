simulator lang=spectre
global 0

ahdl_include "dut.va"

Vvdd (vdd 0) vsource dc=0.9
Vvss (vss 0) vsource dc=0
Vclk (selection_event 0) vsource type=pulse val0=0 val1=0.9 delay=0 rise=50p fall=50p width=1.8n period=4n
Vrst (release_n 0) vsource type=pwl wave=[ 0 0 4n 0 4.1n 0.9 120n 0.9 ]
Vqty0 (qty1_0 0) vsource dc=0.9
Vqty1 (qty1_1 0) vsource dc=0.9
Vqty2 (qty1_2 0) vsource dc=0

XDUT (selection_event release_n qty1_0 qty1_1 qty1_2 vdd vss unit0 unit1 unit2 unit3 unit4 unit5 unit6 unit7) v2_dwa_circular_cursor_007

tran tran stop=120n maxstep=500p
save selection_event release_n qty1_0 qty1_1 qty1_2 unit0 unit1 unit2 unit3 unit4 unit5 unit6 unit7
