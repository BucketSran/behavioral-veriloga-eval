`include "constants.vams"
`include "disciplines.vams"

module v2_binary_dac_not_thermometer_6b_008(weight0, weight1, weight2, weight3, weight4, weight5, vdd, vss, recon_value, glitch_guard);
    input weight0, weight1, weight2, weight3, weight4, weight5, vdd, vss;
    output recon_value, glitch_guard;
    electrical weight0, weight1, weight2, weight3, weight4, weight5, vdd, vss, recon_value, glitch_guard;
    parameter real vth = 0.45;
    parameter real tr = 40p;
    integer code_q;
    real out_t;

    analog begin
        code_q = 0;
        if (V(weight0) >= vth) code_q = code_q + 1;
        if (V(weight1) >= vth) code_q = code_q + 2;
        if (V(weight2) >= vth) code_q = code_q + 4;
        if (V(weight3) >= vth) code_q = code_q + 8;
        if (V(weight4) >= vth) code_q = code_q + 16;
        if (V(weight5) >= vth) code_q = code_q + 32;
        out_t = V(vss) + (V(vdd) - V(vss)) * code_q / 63.0;
        V(recon_value) <+ transition(out_t, 0.0, tr, tr);
        V(glitch_guard) <+ transition(V(vdd), 0.0, tr, tr);
    end
endmodule
