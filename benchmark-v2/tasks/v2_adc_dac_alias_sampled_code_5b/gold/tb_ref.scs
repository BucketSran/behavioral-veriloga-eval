simulator lang=spectre
global 0

ahdl_include "dut.va"

Vvdd (vdd 0) vsource dc=0.9
Vvss (vss 0) vsource dc=0
Vclk (sample_clock 0) vsource type=pulse val0=0 val1=0.9 delay=0 rise=50p fall=50p width=0.9n period=2n
Vrst (clear_n 0) vsource type=pwl wave=[ 0 0 3n 0 3.1n 0.9 90n 0.9 ]
Vvin (measured_level 0) vsource type=pwl wave=[ 0 0 90n 0.9 ]

XDUT (measured_level sample_clock clear_n vdd vss bit4 bit3 bit2 bit1 bit0 held_level) v2_adc_dac_alias_sampled_code_5b

tran tran stop=120n maxstep=500p
save measured_level sample_clock clear_n held_level bit0 bit1 bit2 bit3 bit4
