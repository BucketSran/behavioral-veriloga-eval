`include "constants.vams"
`include "disciplines.vams"

module v2_adc_dac_calibrated_keywordless_5b(sense_value, cadence, clear_n, vdd, vss, dec4, dec3, dec2, dec1, dec0, estimate_level, settled);
    input sense_value, cadence, clear_n, vdd, vss;
    output dec4, dec3, dec2, dec1, dec0, estimate_level, settled;
    electrical sense_value, cadence, clear_n, vdd, vss, dec4, dec3, dec2, dec1, dec0, estimate_level, settled;
    parameter real vth = 0.45;
    parameter real tr = 50p;
    integer code_q;
    real step_q;
    real vout_t;
    real dec0_t;
    real dec1_t;
    real dec2_t;
    real dec3_t;
    real dec4_t;
    integer stable_count;
    real settled_t;
    analog begin
        @(initial_step) begin
            code_q = 0;
            vout_t = V(vss);
            dec0_t = V(vss);
            dec1_t = V(vss);
            dec2_t = V(vss);
            dec3_t = V(vss);
            dec4_t = V(vss);
            stable_count = 0;
            settled_t = V(vss);
        end

        @(cross(V(cadence) - vth, +1)) begin
            if (V(clear_n) < vth) begin
                code_q = 0;
                vout_t = V(vss);
            dec0_t = V(vss);
            dec1_t = V(vss);
            dec2_t = V(vss);
            dec3_t = V(vss);
            dec4_t = V(vss);
            stable_count = 0;
            settled_t = V(vss);
            end else begin
                step_q = (V(vdd) - V(vss)) / 32.0;
                code_q = (V(sense_value) - V(vss)) / step_q;
                if (code_q < 0) code_q = 0;
                if (code_q > 31) code_q = 31;
                vout_t = V(vss) + (V(vdd) - V(vss)) * code_q / 31.0;
            dec0_t = ((code_q & 1) != 0) ? V(vdd) : V(vss);
            dec1_t = ((code_q & 2) != 0) ? V(vdd) : V(vss);
            dec2_t = ((code_q & 4) != 0) ? V(vdd) : V(vss);
            dec3_t = ((code_q & 8) != 0) ? V(vdd) : V(vss);
            dec4_t = ((code_q & 16) != 0) ? V(vdd) : V(vss);
            stable_count = stable_count + 1;
            if (stable_count > 8) settled_t = V(vdd);
            end
        end

        V(dec0) <+ transition(dec0_t, 0.0, tr, tr);
        V(dec1) <+ transition(dec1_t, 0.0, tr, tr);
        V(dec2) <+ transition(dec2_t, 0.0, tr, tr);
        V(dec3) <+ transition(dec3_t, 0.0, tr, tr);
        V(dec4) <+ transition(dec4_t, 0.0, tr, tr);
        V(estimate_level) <+ transition(vout_t, 0.0, tr, tr);
        V(settled) <+ transition(settled_t, 0.0, tr, tr);
    end
endmodule
