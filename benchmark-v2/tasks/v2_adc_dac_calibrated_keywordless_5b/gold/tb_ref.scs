simulator lang=spectre
global 0

ahdl_include "dut.va"

Vvdd (vdd 0) vsource dc=0.9
Vvss (vss 0) vsource dc=0
Vclk (cadence 0) vsource type=pulse val0=0 val1=0.9 delay=0 rise=50p fall=50p width=0.9n period=2n
Vrst (clear_n 0) vsource type=pwl wave=[ 0 0 3n 0 3.1n 0.9 90n 0.9 ]
Vvin (sense_value 0) vsource type=pwl wave=[ 0 0 90n 0.9 ]

XDUT (sense_value cadence clear_n vdd vss dec4 dec3 dec2 dec1 dec0 estimate_level settled) v2_adc_dac_calibrated_keywordless_5b

tran tran stop=120n maxstep=500p
save sense_value cadence clear_n estimate_level dec0 dec1 dec2 dec3 dec4 settled
