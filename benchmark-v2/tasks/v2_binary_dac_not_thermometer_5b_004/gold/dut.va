`include "constants.vams"
`include "disciplines.vams"

module v2_binary_dac_not_thermometer_5b_004(weight0, weight1, weight2, weight3, weight4, vdd, vss, weighted_level, glitch_guard);
    input weight0, weight1, weight2, weight3, weight4, vdd, vss;
    output weighted_level, glitch_guard;
    electrical weight0, weight1, weight2, weight3, weight4, vdd, vss, weighted_level, glitch_guard;
    parameter real vth = 0.45;
    parameter real tr = 40p;
    integer code_q;
    real out_t;

    analog begin
        code_q = 0;
        if (V(weight0) >= vth) code_q = code_q + 1;
        if (V(weight1) >= vth) code_q = code_q + 2;
        if (V(weight2) >= vth) code_q = code_q + 4;
        if (V(weight3) >= vth) code_q = code_q + 8;
        if (V(weight4) >= vth) code_q = code_q + 16;
        out_t = V(vss) + (V(vdd) - V(vss)) * code_q / 31.0;
        V(weighted_level) <+ transition(out_t, 0.0, tr, tr);
        V(glitch_guard) <+ transition(V(vdd), 0.0, tr, tr);
    end
endmodule
