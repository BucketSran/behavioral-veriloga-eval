`include "constants.vams"
`include "disciplines.vams"

module v2_ext_window_detector_017(monitor_node, vdd, vss, inside_window, below_window, above_window);
    input monitor_node, vdd, vss;
    output inside_window, below_window, above_window;
    electrical monitor_node, vdd, vss, inside_window, below_window, above_window;
    parameter real lo = 0.25;
    parameter real hi = 0.65;
    parameter real tr = 40p;
    real inside_t;
    real below_t;
    real above_t;

    analog begin
        below_t = (V(monitor_node) < lo) ? V(vdd) : V(vss);
        above_t = (V(monitor_node) > hi) ? V(vdd) : V(vss);
        inside_t = (V(monitor_node) >= lo && V(monitor_node) <= hi) ? V(vdd) : V(vss);
        V(inside_window) <+ transition(inside_t, 0.0, tr, tr);
        V(below_window) <+ transition(below_t, 0.0, tr, tr);
        V(above_window) <+ transition(above_t, 0.0, tr, tr);
    end
endmodule
