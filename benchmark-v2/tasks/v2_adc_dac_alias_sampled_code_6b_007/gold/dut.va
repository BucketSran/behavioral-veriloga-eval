`include "constants.vams"
`include "disciplines.vams"

module v2_adc_dac_alias_sampled_code_6b_007(external_drive, capture_tick, clear_n, vdd, vss, state5, state4, state3, state2, state1, state0, estimate_node);
    input external_drive, capture_tick, clear_n, vdd, vss;
    output state5, state4, state3, state2, state1, state0, estimate_node;
    electrical external_drive, capture_tick, clear_n, vdd, vss, state5, state4, state3, state2, state1, state0, estimate_node;
    parameter real vth = 0.45;
    parameter real tr = 50p;
    integer code_q;
    real step_q;
    real vout_t;
    real state0_t;
    real state1_t;
    real state2_t;
    real state3_t;
    real state4_t;
    real state5_t;
    analog begin
        @(initial_step) begin
            code_q = 0;
            vout_t = V(vss);
            state0_t = V(vss);
            state1_t = V(vss);
            state2_t = V(vss);
            state3_t = V(vss);
            state4_t = V(vss);
            state5_t = V(vss);
        end

        @(cross(V(capture_tick) - vth, +1)) begin
            if (V(clear_n) < vth) begin
                code_q = 0;
                vout_t = V(vss);
            state0_t = V(vss);
            state1_t = V(vss);
            state2_t = V(vss);
            state3_t = V(vss);
            state4_t = V(vss);
            state5_t = V(vss);
            end else begin
                step_q = (V(vdd) - V(vss)) / 64.0;
                code_q = (V(external_drive) - V(vss)) / step_q;
                if (code_q < 0) code_q = 0;
                if (code_q > 63) code_q = 63;
                vout_t = V(vss) + (V(vdd) - V(vss)) * code_q / 63.0;
            state0_t = ((code_q & 1) != 0) ? V(vdd) : V(vss);
            state1_t = ((code_q & 2) != 0) ? V(vdd) : V(vss);
            state2_t = ((code_q & 4) != 0) ? V(vdd) : V(vss);
            state3_t = ((code_q & 8) != 0) ? V(vdd) : V(vss);
            state4_t = ((code_q & 16) != 0) ? V(vdd) : V(vss);
            state5_t = ((code_q & 32) != 0) ? V(vdd) : V(vss);
            end
        end

        V(state0) <+ transition(state0_t, 0.0, tr, tr);
        V(state1) <+ transition(state1_t, 0.0, tr, tr);
        V(state2) <+ transition(state2_t, 0.0, tr, tr);
        V(state3) <+ transition(state3_t, 0.0, tr, tr);
        V(state4) <+ transition(state4_t, 0.0, tr, tr);
        V(state5) <+ transition(state5_t, 0.0, tr, tr);
        V(estimate_node) <+ transition(vout_t, 0.0, tr, tr);
    end
endmodule
