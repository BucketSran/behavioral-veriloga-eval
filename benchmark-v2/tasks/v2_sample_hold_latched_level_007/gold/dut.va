`include "constants.vams"
`include "disciplines.vams"

module v2_sample_hold_latched_level_007(external_drive, capture_tick, vdd, vss, remembered_level);
    input external_drive, capture_tick, vdd, vss;
    output remembered_level;
    electrical external_drive, capture_tick, vdd, vss, remembered_level;
    parameter real vth = 0.45;
    parameter real tr = 50p;
    real held_v;

    analog begin
        @(initial_step) begin
            held_v = V(vss);
        end

        @(cross(V(capture_tick) - vth, +1)) begin
            held_v = V(external_drive);
        end

        V(remembered_level) <+ transition(held_v, 0.0, tr, tr);
    end
endmodule
