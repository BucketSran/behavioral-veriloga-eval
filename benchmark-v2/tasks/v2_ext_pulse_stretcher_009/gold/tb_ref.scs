simulator lang=spectre
global 0

ahdl_include "dut.va"

Vvdd (vdd 0) vsource dc=0.9
Vvss (vss 0) vsource dc=0
Vtrig (event_in 0) vsource type=pulse val0=0 val1=0.9 delay=2n rise=50p fall=50p width=1n period=14n

XDUT (event_in vdd vss stretched_pulse) v2_ext_pulse_stretcher_009

tran tran stop=120n maxstep=500p
save event_in stretched_pulse
