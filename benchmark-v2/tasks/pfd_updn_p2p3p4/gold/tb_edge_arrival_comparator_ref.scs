simulator lang=spectre
global 0
Vvdd (supply_hi 0) vsource dc=0.9 type=dc
Vvss (supply_lo 0) vsource dc=0.0 type=dc
Vearly (early_edge 0) vsource type=pulse val0=0 val1=0.9 period=20n width=10n rise=100p fall=100p
Vlate (late_edge 0) vsource type=pulse val0=0 val1=0.9 period=20n delay=3n width=10n rise=100p fall=100p
IDUT (supply_hi supply_lo early_edge late_edge adv ret) edge_arrival_comparator vth=0.45 tedge=50p
simulatorOptions options reltol=1e-4 vabstol=1e-6 iabstol=1e-12 temp=27 tnom=27 gmin=1e-12
tran tran stop=300n maxstep=100p errpreset=conservative
save early_edge late_edge adv ret
ahdl_include "./edge_arrival_comparator.va"
