`include "constants.vams"
`include "disciplines.vams"

module v2_event_counter_not_async_007(capture_tick, clear_n, vdd, vss, feedback_tick);
    input capture_tick, clear_n, vdd, vss;
    output feedback_tick;
    electrical capture_tick, clear_n, vdd, vss, feedback_tick;
    parameter real vth = 0.45;
    parameter real tr = 40p;
    integer div_count_q;
    integer count_state_q;
    integer out_q;
    integer ratio_q;

    analog begin
        @(initial_step) begin
            div_count_q = 0;
            count_state_q = 0;
            out_q = 0;
            ratio_q = 4;
        end

        @(cross(V(capture_tick) - vth, +1)) begin
            if (V(clear_n) < vth) begin
                div_count_q = 0;
                count_state_q = 0;
                out_q = 0;
            end else begin
                ratio_q = 4;
                count_state_q = (count_state_q + 1) % 16;
                div_count_q = div_count_q + 1;
                if (div_count_q >= ratio_q) begin
                    div_count_q = 0;
                    out_q = !out_q;
                end

            end
        end

        V(feedback_tick) <+ transition(out_q ? V(vdd) : V(vss), 0.0, tr, tr);

    end
endmodule
