`include "constants.vams"
`include "disciplines.vams"

module v2_sample_hold_latched_level_005(sense_level, cadence, vdd, vss, held_sample);
    input sense_level, cadence, vdd, vss;
    output held_sample;
    electrical sense_level, cadence, vdd, vss, held_sample;
    parameter real vth = 0.45;
    parameter real tr = 50p;
    real held_v;

    analog begin
        @(initial_step) begin
            held_v = V(vss);
        end

        @(cross(V(cadence) - vth, +1)) begin
            held_v = V(sense_level);
        end

        V(held_sample) <+ transition(held_v, 0.0, tr, tr);
    end
endmodule
