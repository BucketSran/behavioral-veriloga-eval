simulator lang=spectre
global 0
ahdl_include "level_to_code_converter.va"
Vvdd (supply_hi 0) vsource dc=0.9 type=dc
Vvss (supply_lo 0) vsource dc=0.0 type=dc
Vvin (analog_level 0) vsource type=pwl wave=[0 0 800e-9 0.9]
Vclk (sample_strobe 0) vsource type=pulse val0=0 val1=0.9 period=10n width=5n rise=100p fall=100p
IDUT (supply_hi supply_lo analog_level sample_strobe qb2 qb1 qb0) level_to_code_converter ref_hi=0.9 ref_lo=0.0 vth=0.45 tedge=100p
tran tran stop=820n maxstep=2n
save analog_level sample_strobe qb2 qb1 qb0
