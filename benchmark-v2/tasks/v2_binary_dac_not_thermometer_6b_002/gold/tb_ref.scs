simulator lang=spectre
global 0

ahdl_include "dut.va"

Vvdd (vdd 0) vsource dc=0.9
Vvss (vss 0) vsource dc=0
Vscale0 (scale0 0) vsource type=pulse val0=0 val1=0.9 delay=1n rise=50p fall=50p width=1n period=2n
Vscale1 (scale1 0) vsource type=pulse val0=0 val1=0.9 delay=1n rise=50p fall=50p width=2n period=4n
Vscale2 (scale2 0) vsource type=pulse val0=0 val1=0.9 delay=1n rise=50p fall=50p width=4n period=8n
Vscale3 (scale3 0) vsource type=pulse val0=0 val1=0.9 delay=1n rise=50p fall=50p width=8n period=16n
Vscale4 (scale4 0) vsource type=pulse val0=0 val1=0.9 delay=1n rise=50p fall=50p width=16n period=32n
Vscale5 (scale5 0) vsource type=pulse val0=0 val1=0.9 delay=1n rise=50p fall=50p width=32n period=64n

XDUT (scale0 scale1 scale2 scale3 scale4 scale5 vdd vss recon_value) v2_binary_dac_not_thermometer_6b_002

tran tran stop=120n maxstep=500p
save scale0 scale1 scale2 scale3 scale4 scale5 recon_value
