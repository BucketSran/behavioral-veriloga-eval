simulator lang=spectre
global 0

ahdl_include "dut.va"

Vvdd (vdd 0) vsource dc=0.9
Vvss (vss 0) vsource dc=0
Vclk (advance_edge 0) vsource type=pulse val0=0 val1=0.9 delay=0 rise=50p fall=50p width=0.9n period=2n
Vrst (clear_n 0) vsource type=pwl wave=[ 0 0 3n 0 3.1n 0.9 90n 0.9 ]
Vvin (observed_level 0) vsource type=pwl wave=[ 0 0 90n 0.9 ]

XDUT (observed_level advance_edge clear_n vdd vss mark5 mark4 mark3 mark2 mark1 mark0 drive_estimate) v2_adc_dac_alias_sampled_code_6b_003

tran tran stop=120n maxstep=500p
save observed_level advance_edge clear_n drive_estimate mark0 mark1 mark2 mark3 mark4 mark5
