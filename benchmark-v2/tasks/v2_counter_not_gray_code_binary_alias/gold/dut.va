`include "constants.vams"
`include "disciplines.vams"

module v2_counter_not_gray_code_binary_alias(advance, clear_n, vdd, vss, tick_out, cnt0, cnt1, cnt2, cnt3);
    input advance, clear_n, vdd, vss;
    output tick_out, cnt0, cnt1, cnt2, cnt3;
    electrical advance, clear_n, vdd, vss, tick_out, cnt0, cnt1, cnt2, cnt3;
    parameter real vth = 0.45;
    parameter real tr = 40p;
    integer div_count_q;
    integer count_state_q;
    integer out_q;
    integer ratio_q;
    real cnt0_t;
    real cnt1_t;
    real cnt2_t;
    real cnt3_t;

    analog begin
        @(initial_step) begin
            div_count_q = 0;
            count_state_q = 0;
            out_q = 0;
            ratio_q = 3;
        end

        @(cross(V(advance) - vth, +1)) begin
            if (V(clear_n) < vth) begin
                div_count_q = 0;
                count_state_q = 0;
                out_q = 0;
            end else begin
                ratio_q = 3;
                count_state_q = (count_state_q + 1) % 16;
                div_count_q = div_count_q + 1;
                if (div_count_q >= ratio_q) begin
                    div_count_q = 0;
                    out_q = !out_q;
                end
                cnt0_t = ((count_state_q & 1) != 0) ? V(vdd) : V(vss);
                cnt1_t = ((count_state_q & 2) != 0) ? V(vdd) : V(vss);
                cnt2_t = ((count_state_q & 4) != 0) ? V(vdd) : V(vss);
                cnt3_t = ((count_state_q & 8) != 0) ? V(vdd) : V(vss);
            end
        end

        V(tick_out) <+ transition(out_q ? V(vdd) : V(vss), 0.0, tr, tr);
        V(cnt0) <+ transition(cnt0_t, 0.0, tr, tr);
        V(cnt1) <+ transition(cnt1_t, 0.0, tr, tr);
        V(cnt2) <+ transition(cnt2_t, 0.0, tr, tr);
        V(cnt3) <+ transition(cnt3_t, 0.0, tr, tr);
    end
endmodule
