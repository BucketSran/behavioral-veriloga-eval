simulator lang=spectre
global 0

ahdl_include "dut.va"

Vvdd (vdd 0) vsource dc=0.9
Vvss (vss 0) vsource dc=0
Vclk (cadence 0) vsource type=pulse val0=0 val1=0.9 delay=0 rise=50p fall=50p width=0.9n period=2n
Vrst (clear_n 0) vsource type=pwl wave=[ 0 0 3n 0 3.1n 0.9 90n 0.9 ]
Vvin (external_drive 0) vsource type=pwl wave=[ 0 0 90n 0.9 ]

XDUT (external_drive cadence clear_n vdd vss q3 q2 q1 q0 reconstructed_level settled) v2_adc_dac_calibrated_chain_settled

tran tran stop=120n maxstep=50p
save external_drive cadence clear_n reconstructed_level q0 q1 q2 q3 settled
