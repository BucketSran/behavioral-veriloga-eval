`include "constants.vams"
`include "disciplines.vams"

module v2_dwa_circular_cursor_014(next_window, clear_n, qty2_0, qty2_1, qty2_2, vdd, vss, cell0, cell1, cell2, cell3, cell4, cell5, cell6, cell7);
    input next_window, clear_n, qty2_0, qty2_1, qty2_2, vdd, vss;
    output cell0, cell1, cell2, cell3, cell4, cell5, cell6, cell7;
    electrical next_window, clear_n, qty2_0, qty2_1, qty2_2, vdd, vss, cell0, cell1, cell2, cell3, cell4, cell5, cell6, cell7;
    parameter real vth = 0.45;
    parameter real tr = 50p;
    integer ptr_q;
    integer count_q;
    integer prev_count_q;
    integer idx_q;
    real cell0_t;
    real cell1_t;
    real cell2_t;
    real cell3_t;
    real cell4_t;
    real cell5_t;
    real cell6_t;
    real cell7_t;

    analog begin
        @(initial_step) begin
            ptr_q = 0;
            count_q = 3;
            prev_count_q = 3;
                cell0_t = V(vss);
                cell1_t = V(vss);
                cell2_t = V(vss);
                cell3_t = V(vss);
                cell4_t = V(vss);
                cell5_t = V(vss);
                cell6_t = V(vss);
                cell7_t = V(vss);
        end

        @(cross(V(next_window) - vth, +1)) begin
            if (V(clear_n) < vth) begin
                ptr_q = 0;
                prev_count_q = 3;
            end else begin
                ptr_q = (ptr_q + prev_count_q) % 8;
            end
            count_q = 0;
                if (V(qty2_0) >= vth) count_q = count_q + 1;
                if (V(qty2_1) >= vth) count_q = count_q + 2;
                if (V(qty2_2) >= vth) count_q = count_q + 4;
            if (count_q < 1) count_q = 1;
            if (count_q > 4) count_q = 4;
                cell0_t = V(vss);
                cell1_t = V(vss);
                cell2_t = V(vss);
                cell3_t = V(vss);
                cell4_t = V(vss);
                cell5_t = V(vss);
                cell6_t = V(vss);
                cell7_t = V(vss);
                idx_q = (ptr_q + 0) % 8;
                if (count_q > 0 && idx_q == 0) cell0_t = V(vdd);
                if (count_q > 0 && idx_q == 1) cell1_t = V(vdd);
                if (count_q > 0 && idx_q == 2) cell2_t = V(vdd);
                if (count_q > 0 && idx_q == 3) cell3_t = V(vdd);
                if (count_q > 0 && idx_q == 4) cell4_t = V(vdd);
                if (count_q > 0 && idx_q == 5) cell5_t = V(vdd);
                if (count_q > 0 && idx_q == 6) cell6_t = V(vdd);
                if (count_q > 0 && idx_q == 7) cell7_t = V(vdd);
                idx_q = (ptr_q + 1) % 8;
                if (count_q > 1 && idx_q == 0) cell0_t = V(vdd);
                if (count_q > 1 && idx_q == 1) cell1_t = V(vdd);
                if (count_q > 1 && idx_q == 2) cell2_t = V(vdd);
                if (count_q > 1 && idx_q == 3) cell3_t = V(vdd);
                if (count_q > 1 && idx_q == 4) cell4_t = V(vdd);
                if (count_q > 1 && idx_q == 5) cell5_t = V(vdd);
                if (count_q > 1 && idx_q == 6) cell6_t = V(vdd);
                if (count_q > 1 && idx_q == 7) cell7_t = V(vdd);
                idx_q = (ptr_q + 2) % 8;
                if (count_q > 2 && idx_q == 0) cell0_t = V(vdd);
                if (count_q > 2 && idx_q == 1) cell1_t = V(vdd);
                if (count_q > 2 && idx_q == 2) cell2_t = V(vdd);
                if (count_q > 2 && idx_q == 3) cell3_t = V(vdd);
                if (count_q > 2 && idx_q == 4) cell4_t = V(vdd);
                if (count_q > 2 && idx_q == 5) cell5_t = V(vdd);
                if (count_q > 2 && idx_q == 6) cell6_t = V(vdd);
                if (count_q > 2 && idx_q == 7) cell7_t = V(vdd);
                idx_q = (ptr_q + 3) % 8;
                if (count_q > 3 && idx_q == 0) cell0_t = V(vdd);
                if (count_q > 3 && idx_q == 1) cell1_t = V(vdd);
                if (count_q > 3 && idx_q == 2) cell2_t = V(vdd);
                if (count_q > 3 && idx_q == 3) cell3_t = V(vdd);
                if (count_q > 3 && idx_q == 4) cell4_t = V(vdd);
                if (count_q > 3 && idx_q == 5) cell5_t = V(vdd);
                if (count_q > 3 && idx_q == 6) cell6_t = V(vdd);
                if (count_q > 3 && idx_q == 7) cell7_t = V(vdd);
            prev_count_q = count_q;
        end

        V(cell0) <+ transition(cell0_t, 0.0, tr, tr);
        V(cell1) <+ transition(cell1_t, 0.0, tr, tr);
        V(cell2) <+ transition(cell2_t, 0.0, tr, tr);
        V(cell3) <+ transition(cell3_t, 0.0, tr, tr);
        V(cell4) <+ transition(cell4_t, 0.0, tr, tr);
        V(cell5) <+ transition(cell5_t, 0.0, tr, tr);
        V(cell6) <+ transition(cell6_t, 0.0, tr, tr);
        V(cell7) <+ transition(cell7_t, 0.0, tr, tr);
    end
endmodule
