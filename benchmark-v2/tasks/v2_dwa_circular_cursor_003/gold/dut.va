`include "constants.vams"
`include "disciplines.vams"

module v2_dwa_circular_cursor_003(selection_event, release_n, qty0_0, qty0_1, qty0_2, vdd, vss, unit0, unit1, unit2, unit3, unit4, unit5, unit6, unit7);
    input selection_event, release_n, qty0_0, qty0_1, qty0_2, vdd, vss;
    output unit0, unit1, unit2, unit3, unit4, unit5, unit6, unit7;
    electrical selection_event, release_n, qty0_0, qty0_1, qty0_2, vdd, vss, unit0, unit1, unit2, unit3, unit4, unit5, unit6, unit7;
    parameter real vth = 0.45;
    parameter real tr = 50p;
    integer ptr_q;
    integer count_q;
    integer prev_count_q;
    integer idx_q;
    real unit0_t;
    real unit1_t;
    real unit2_t;
    real unit3_t;
    real unit4_t;
    real unit5_t;
    real unit6_t;
    real unit7_t;

    analog begin
        @(initial_step) begin
            ptr_q = 0;
            count_q = 3;
            prev_count_q = 3;
                unit0_t = V(vss);
                unit1_t = V(vss);
                unit2_t = V(vss);
                unit3_t = V(vss);
                unit4_t = V(vss);
                unit5_t = V(vss);
                unit6_t = V(vss);
                unit7_t = V(vss);
        end

        @(cross(V(selection_event) - vth, +1)) begin
            if (V(release_n) < vth) begin
                ptr_q = 0;
                prev_count_q = 3;
            end else begin
                ptr_q = (ptr_q + prev_count_q) % 8;
            end
            count_q = 0;
                if (V(qty0_0) >= vth) count_q = count_q + 1;
                if (V(qty0_1) >= vth) count_q = count_q + 2;
                if (V(qty0_2) >= vth) count_q = count_q + 4;
            if (count_q < 1) count_q = 1;
            if (count_q > 4) count_q = 4;
                unit0_t = V(vss);
                unit1_t = V(vss);
                unit2_t = V(vss);
                unit3_t = V(vss);
                unit4_t = V(vss);
                unit5_t = V(vss);
                unit6_t = V(vss);
                unit7_t = V(vss);
                idx_q = (ptr_q + 0) % 8;
                if (count_q > 0 && idx_q == 0) unit0_t = V(vdd);
                if (count_q > 0 && idx_q == 1) unit1_t = V(vdd);
                if (count_q > 0 && idx_q == 2) unit2_t = V(vdd);
                if (count_q > 0 && idx_q == 3) unit3_t = V(vdd);
                if (count_q > 0 && idx_q == 4) unit4_t = V(vdd);
                if (count_q > 0 && idx_q == 5) unit5_t = V(vdd);
                if (count_q > 0 && idx_q == 6) unit6_t = V(vdd);
                if (count_q > 0 && idx_q == 7) unit7_t = V(vdd);
                idx_q = (ptr_q + 1) % 8;
                if (count_q > 1 && idx_q == 0) unit0_t = V(vdd);
                if (count_q > 1 && idx_q == 1) unit1_t = V(vdd);
                if (count_q > 1 && idx_q == 2) unit2_t = V(vdd);
                if (count_q > 1 && idx_q == 3) unit3_t = V(vdd);
                if (count_q > 1 && idx_q == 4) unit4_t = V(vdd);
                if (count_q > 1 && idx_q == 5) unit5_t = V(vdd);
                if (count_q > 1 && idx_q == 6) unit6_t = V(vdd);
                if (count_q > 1 && idx_q == 7) unit7_t = V(vdd);
                idx_q = (ptr_q + 2) % 8;
                if (count_q > 2 && idx_q == 0) unit0_t = V(vdd);
                if (count_q > 2 && idx_q == 1) unit1_t = V(vdd);
                if (count_q > 2 && idx_q == 2) unit2_t = V(vdd);
                if (count_q > 2 && idx_q == 3) unit3_t = V(vdd);
                if (count_q > 2 && idx_q == 4) unit4_t = V(vdd);
                if (count_q > 2 && idx_q == 5) unit5_t = V(vdd);
                if (count_q > 2 && idx_q == 6) unit6_t = V(vdd);
                if (count_q > 2 && idx_q == 7) unit7_t = V(vdd);
                idx_q = (ptr_q + 3) % 8;
                if (count_q > 3 && idx_q == 0) unit0_t = V(vdd);
                if (count_q > 3 && idx_q == 1) unit1_t = V(vdd);
                if (count_q > 3 && idx_q == 2) unit2_t = V(vdd);
                if (count_q > 3 && idx_q == 3) unit3_t = V(vdd);
                if (count_q > 3 && idx_q == 4) unit4_t = V(vdd);
                if (count_q > 3 && idx_q == 5) unit5_t = V(vdd);
                if (count_q > 3 && idx_q == 6) unit6_t = V(vdd);
                if (count_q > 3 && idx_q == 7) unit7_t = V(vdd);
            prev_count_q = count_q;
        end

        V(unit0) <+ transition(unit0_t, 0.0, tr, tr);
        V(unit1) <+ transition(unit1_t, 0.0, tr, tr);
        V(unit2) <+ transition(unit2_t, 0.0, tr, tr);
        V(unit3) <+ transition(unit3_t, 0.0, tr, tr);
        V(unit4) <+ transition(unit4_t, 0.0, tr, tr);
        V(unit5) <+ transition(unit5_t, 0.0, tr, tr);
        V(unit6) <+ transition(unit6_t, 0.0, tr, tr);
        V(unit7) <+ transition(unit7_t, 0.0, tr, tr);
    end
endmodule
