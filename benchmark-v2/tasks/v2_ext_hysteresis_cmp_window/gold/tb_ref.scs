simulator lang=spectre
global 0

ahdl_include "dut.va"

Vin (vin 0) vsource type=pwl wave=[0n 0.0  40n 1.0  60n 1.0  95n 0.0  120n 0.0]
Xdut (vin vout) hysteresis_cmp_window

tran tran stop=120n maxstep=100p
save vin vout
