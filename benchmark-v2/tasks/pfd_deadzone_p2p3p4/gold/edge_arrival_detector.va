// Edge arrival detector - EVAS-compatible
// Detects which of two edge-carrying inputs arrives first.
// First arriving edge asserts its corresponding output flag.
// When both flags are asserted, a reset path clears both.
// Pure voltage-domain.

`include "constants.vams"
`include "disciplines.vams"

`default_transition 10p

module edge_arrival_detector(
    inout  electrical VDD,
    inout  electrical VSS,
    input  electrical first_edge,
    input  electrical second_edge,
    output electrical lead_flag,
    output electrical dn
);

parameter real vth   = 0.45;
parameter real tedge = 20p;

integer lead_level;
integer dn_level;

analog begin
    @(initial_step) begin
        lead_level = 0;
        dn_level   = 0;
    end

    @(cross(V(first_edge)  - vth, +1)) begin
        lead_level = 1;
    end
    @(cross(V(second_edge) - vth, +1)) begin
        dn_level = 1;
    end

    // Combinational reset: when both are high, clear both
    if (lead_level && dn_level) begin
        lead_level = 0;
        dn_level   = 0;
    end

    V(dn)        <+ transition(dn_level   ? V(VDD) : V(VSS), 0, tedge, tedge);
    V(lead_flag) <+ transition(lead_level ? V(VDD) : V(VSS), 0, tedge, tedge);
end

endmodule
