simulator lang=spectre
global 0

Vvdd (vdd 0) vsource dc=0.9 type=dc
Vvss (vss 0) vsource dc=0.0 type=dc

// Lead pulses: 5 UP pulses, then quiet
Vlead (lead_pulse 0) vsource type=pwl wave=[0 0  10e-9 0  10.1e-9 0.9  20e-9 0.9  20.1e-9 0  30e-9 0  30.1e-9 0.9  40e-9 0.9  40.1e-9 0  50e-9 0  50.1e-9 0.9  60e-9 0.9  60.1e-9 0  70e-9 0  70.1e-9 0.9  80e-9 0.9  80.1e-9 0  90e-9 0  90.1e-9 0.9  100e-9 0.9  100.1e-9 0  300e-9 0]

// Lag pulses: 3 DN pulses starting after the UP train
Vlag (lag_pulse 0) vsource type=pwl wave=[0 0  150e-9 0  150.1e-9 0.9  160e-9 0.9  160.1e-9 0  170e-9 0  170.1e-9 0.9  180e-9 0.9  180.1e-9 0  190e-9 0  190.1e-9 0.9  200e-9 0.9  200.1e-9 0  300e-9 0]

IDUT (vdd vss lead_pulse lag_pulse pump_out) charge_pump vth=0.45 charge_step=0.02 tedge=50p

simulatorOptions options reltol=1e-4 vabstol=1e-6 iabstol=1e-12 temp=27 tnom=27 gmin=1e-12

tran tran stop=300n maxstep=1n

save lead_pulse lag_pulse pump_out

ahdl_include "./charge_pump.va"
