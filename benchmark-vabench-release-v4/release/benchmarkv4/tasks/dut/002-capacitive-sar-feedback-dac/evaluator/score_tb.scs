simulator lang=spectre
global 0

ahdl_include "./dut/cdac_cal.va"

Vvdd (VDD 0) vsource dc=0.9
Vvss (VSS 0) vsource dc=0
Vclk (CLK 0) vsource type=pulse val0=0 val1=0.9 delay=1n rise=20p fall=20p width=1n period=4n
Vd0 (D0 0) vsource type=pwl wave=[0n 0 2n 0 5.9n 0 6n 0.9 9.9n 0.9 10n 0 13.9n 0 14n 0.9 17.9n 0.9 18n 0.9 21.9n 0.9 22n 0.9 25.9n 0.9 26n 0 29.9n 0 30n 0 33.9n 0 34n 0 37.9n 0 38n 0 41.9n 0 42n 0 45.9n 0 46n 0 49.9n 0 50n 0.9 53.9n 0.9 54n 0.9 57.9n 0.9 58n 0.9 61.9n 0.9 62n 0.9 68n 0.9]
Vd1 (D1 0) vsource type=pwl wave=[0n 0 2n 0 5.9n 0 6n 0 9.9n 0 10n 0.9 13.9n 0.9 14n 0.9 17.9n 0.9 18n 0.9 21.9n 0.9 22n 0.9 25.9n 0.9 26n 0 29.9n 0 30n 0 33.9n 0 34n 0 37.9n 0 38n 0 41.9n 0 42n 0 45.9n 0 46n 0 49.9n 0 50n 0.9 53.9n 0.9 54n 0.9 57.9n 0.9 58n 0.9 61.9n 0.9 62n 0.9 68n 0.9]
Vd2 (D2 0) vsource type=pwl wave=[0n 0 2n 0 5.9n 0 6n 0 9.9n 0 10n 0 13.9n 0 14n 0 17.9n 0 18n 0.9 21.9n 0.9 22n 0.9 25.9n 0.9 26n 0 29.9n 0 30n 0 33.9n 0 34n 0 37.9n 0 38n 0 41.9n 0 42n 0 45.9n 0 46n 0 49.9n 0 50n 0.9 53.9n 0.9 54n 0.9 57.9n 0.9 58n 0.9 61.9n 0.9 62n 0.9 68n 0.9]
Vd3 (D3 0) vsource type=pwl wave=[0n 0 2n 0 5.9n 0 6n 0 9.9n 0 10n 0 13.9n 0 14n 0 17.9n 0 18n 0 21.9n 0 22n 0.9 25.9n 0.9 26n 0 29.9n 0 30n 0 33.9n 0 34n 0 37.9n 0 38n 0 41.9n 0 42n 0 45.9n 0 46n 0 49.9n 0 50n 0.9 53.9n 0.9 54n 0.9 57.9n 0.9 58n 0.9 61.9n 0.9 62n 0.9 68n 0.9]
Vd4 (D4 0) vsource type=pwl wave=[0n 0 2n 0 5.9n 0 6n 0 9.9n 0 10n 0 13.9n 0 14n 0 17.9n 0 18n 0 21.9n 0 22n 0 25.9n 0 26n 0.9 29.9n 0.9 30n 0 33.9n 0 34n 0 37.9n 0 38n 0 41.9n 0 42n 0 45.9n 0 46n 0 49.9n 0 50n 0.9 53.9n 0.9 54n 0.9 57.9n 0.9 58n 0.9 61.9n 0.9 62n 0.9 68n 0.9]
Vd5 (D5 0) vsource type=pwl wave=[0n 0 2n 0 5.9n 0 6n 0 9.9n 0 10n 0 13.9n 0 14n 0 17.9n 0 18n 0 21.9n 0 22n 0 25.9n 0 26n 0 29.9n 0 30n 0.9 33.9n 0.9 34n 0 37.9n 0 38n 0 41.9n 0 42n 0 45.9n 0 46n 0 49.9n 0 50n 0.9 53.9n 0.9 54n 0.9 57.9n 0.9 58n 0.9 61.9n 0.9 62n 0.9 68n 0.9]
Vd6 (D6 0) vsource type=pwl wave=[0n 0 2n 0 5.9n 0 6n 0 9.9n 0 10n 0 13.9n 0 14n 0 17.9n 0 18n 0 21.9n 0 22n 0 25.9n 0 26n 0 29.9n 0 30n 0 33.9n 0 34n 0.9 37.9n 0.9 38n 0 41.9n 0 42n 0 45.9n 0 46n 0 49.9n 0 50n 0.9 53.9n 0.9 54n 0.9 57.9n 0.9 58n 0.9 61.9n 0.9 62n 0.9 68n 0.9]
Vd7 (D7 0) vsource type=pwl wave=[0n 0 2n 0 5.9n 0 6n 0 9.9n 0 10n 0 13.9n 0 14n 0 17.9n 0 18n 0 21.9n 0 22n 0 25.9n 0 26n 0 29.9n 0 30n 0 33.9n 0 34n 0 37.9n 0 38n 0.9 41.9n 0.9 42n 0 45.9n 0 46n 0 49.9n 0 50n 0.9 53.9n 0.9 54n 0.9 57.9n 0.9 58n 0.9 61.9n 0.9 62n 0.9 68n 0.9]
Vd8 (D8 0) vsource type=pwl wave=[0n 0 2n 0 5.9n 0 6n 0 9.9n 0 10n 0 13.9n 0 14n 0 17.9n 0 18n 0 21.9n 0 22n 0 25.9n 0 26n 0 29.9n 0 30n 0 33.9n 0 34n 0 37.9n 0 38n 0 41.9n 0 42n 0.9 45.9n 0.9 46n 0 49.9n 0 50n 0 53.9n 0 54n 0.9 57.9n 0.9 58n 0 61.9n 0 62n 0.9 68n 0.9]
Vd9 (D9 0) vsource type=pwl wave=[0n 0 2n 0 5.9n 0 6n 0 9.9n 0 10n 0 13.9n 0 14n 0 17.9n 0 18n 0 21.9n 0 22n 0 25.9n 0 26n 0 29.9n 0 30n 0 33.9n 0 34n 0 37.9n 0 38n 0 41.9n 0 42n 0 45.9n 0 46n 0.9 49.9n 0.9 50n 0 53.9n 0 54n 0 57.9n 0 58n 0.9 61.9n 0.9 62n 0.9 68n 0.9]
Vcal0 (CAL0 0) vsource type=pwl wave=[0n 0 2n 0 5.9n 0 6n 0.9 9.9n 0.9 10n 0 13.9n 0 14n 0.9 17.9n 0.9 18n 0 21.9n 0 22n 0.9 25.9n 0.9 26n 0 29.9n 0 30n 0.9 33.9n 0.9 34n 0 37.9n 0 38n 0.9 41.9n 0.9 42n 0 45.9n 0 46n 0.9 49.9n 0.9 50n 0 53.9n 0 54n 0.9 57.9n 0.9 58n 0 61.9n 0 62n 0.9 68n 0.9]
Vcal1 (CAL1 0) vsource type=pwl wave=[0n 0 2n 0 5.9n 0 6n 0 9.9n 0 10n 0.9 13.9n 0.9 14n 0.9 17.9n 0.9 18n 0 21.9n 0 22n 0 25.9n 0 26n 0.9 29.9n 0.9 30n 0.9 33.9n 0.9 34n 0 37.9n 0 38n 0 41.9n 0 42n 0.9 45.9n 0.9 46n 0.9 49.9n 0.9 50n 0 53.9n 0 54n 0 57.9n 0 58n 0.9 61.9n 0.9 62n 0.9 68n 0.9]

XDUT (VDD VSS CLK D9 D8 D7 D6 D5 D4 D3 D2 D1 D0 CAL0 CAL1 VDAC_P VDAC_N) cdac_cal

tran tran stop=68n maxstep=20p
save VDD VSS CLK D9 D8 D7 D6 D5 D4 D3 D2 D1 D0 CAL0 CAL1 VDAC_P VDAC_N
