simulator lang=spectre
global 0

ahdl_include "./dut/ideal_dac_4bit_differential.va"

Vclk (clk 0) vsource type=pwl wave=[0 1 1n 1 1.1n 0 3n 0 3.1n 1 11n 1 11.1n 0 13n 0 13.1n 1 21n 1 21.1n 0 23n 0 23.1n 1 31n 1 31.1n 0 33n 0 33.1n 1 38n 1]
Vdig (digital 0) vsource type=pwl wave=[0 2 7n 2 7.1n 7 17n 7 17.1n 12 27n 12 27.1n 15 38n 15]
Vcm (vcm 0) vsource dc=0.6

XDUT (clk digital vcm vop von) ideal_dac_4bit_differential

tran tran stop=36n maxstep=20p
save clk digital vcm von vop
