simulator lang=spectre
global 0

ahdl_include "./dut/event_reacquire_lock_detector.va"

Vref (ref_clk 0) vsource type=pwl wave=[0 0 0.77n 0 0.8n 0.9 1.22n 0.9 1.25n 0 2.77n 0 2.8n 0.9 3.22n 0.9 3.25n 0 4.77n 0 4.8n 0.9 5.22n 0.9 5.25n 0 6.77n 0 6.8n 0.9 7.22n 0.9 7.25n 0 8.77n 0 8.8n 0.9 9.22n 0.9 9.25n 0 10.77n 0 10.8n 0.9 11.22n 0.9 11.25n 0 12.77n 0 12.8n 0.9 13.22n 0.9 13.25n 0 14.77n 0 14.8n 0.9 15.22n 0.9 15.25n 0 16.77n 0 16.8n 0.9 17.22n 0.9 17.25n 0 18.77n 0 18.8n 0.9 19.22n 0.9 19.25n 0 20.77n 0 20.8n 0.9 21.22n 0.9 21.25n 0 23n 0]
Vfb (fb_clk 0) vsource type=pwl wave=[0 0 1.32n 0 1.35n 0.9 1.73n 0.9 1.76n 0 2.89n 0 2.92n 0.9 3.3n 0.9 3.33n 0 4.92n 0 4.95n 0.9 5.33n 0.9 5.36n 0 6.9n 0 6.93n 0.9 7.31n 0.9 7.34n 0 8.91n 0 8.94n 0.9 9.32n 0.9 9.35n 0 12.9n 0 12.93n 0.9 13.31n 0.9 13.34n 0 14.92n 0 14.95n 0.9 15.33n 0.9 15.36n 0 16.93n 0 16.96n 0.9 17.34n 0.9 17.37n 0 18.02n 0 18.05n 0.9 18.43n 0.9 18.46n 0 20.91n 0 20.94n 0.9 21.32n 0.9 21.35n 0 22.37n 0 22.4n 0.9 22.78n 0.9 22.81n 0 23n 0]
Vrst (rst 0) vsource type=pwl wave=[0 0 9.7n 0 9.75n 0.9 11.35n 0.9 11.4n 0 23n 0]

XDUT (ref_clk fb_clk rst lock phase_metric state_mon) event_reacquire_lock_detector

tran tran stop=23n maxstep=10p
save fb_clk lock phase_metric ref_clk rst state_mon
