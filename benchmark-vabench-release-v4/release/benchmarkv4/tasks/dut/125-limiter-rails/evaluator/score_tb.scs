simulator lang=spectre
global 0

ahdl_include "./dut/limiter_rails.va"

Vdd (vdd 0) vsource dc=1.0
Vss (vss 0) vsource dc=-0.1
Vmax (vmax 0) vsource dc=0.25
Vmin (vmin 0) vsource dc=0.15
Vin (vin 0) vsource type=pwl wave=[0 -0.2 8n -0.2 8.1n 0.35 18n 0.35 18.1n 0.95 28n 0.95 28.1n 0.05 38n 0.05 38.1n 0.75 45n 0.75]

XDUT (vdd vss vin vmax vmin vout) limiter_rails

tran tran stop=40n maxstep=25p
save vdd vin vmax vmin vout vss
