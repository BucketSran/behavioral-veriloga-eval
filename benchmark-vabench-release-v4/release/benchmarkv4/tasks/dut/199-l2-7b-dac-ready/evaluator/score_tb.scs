simulator lang=spectre
global 0

ahdl_include "./dut/l2_7b_dac_ready.va"

Vrdy (rdy 0) vsource type=pulse val0=0 val1=0.9 delay=0.3n period=0.8n width=0.32n rise=20p fall=20p
Vd1 (din1 0) vsource type=pwl wave=[0 0.9 0.95n 0.9 1n 0 1.75n 0 1.8n 0.9 2.55n 0.9 2.6n 0 3.35n 0 3.4n 0.9 4.15n 0.9 4.2n 0 4.6n 0]
Vd2 (din2 0) vsource type=pwl wave=[0 0.9 0.95n 0.9 1n 0 2.55n 0 2.6n 0.9 3.35n 0.9 3.4n 0.9 4.15n 0.9 4.2n 0 4.6n 0]
Vd3 (din3 0) vsource type=pwl wave=[0 0.9 0.95n 0.9 1n 0 1.75n 0 1.8n 0.9 2.55n 0.9 2.6n 0 3.35n 0 3.4n 0.9 4.6n 0.9]
Vd4 (din4 0) vsource type=pwl wave=[0 0.9 0.95n 0.9 1n 0 2.55n 0 2.6n 0.9 3.35n 0.9 3.4n 0 4.15n 0 4.2n 0.9 4.6n 0.9]
Vd5 (din5 0) vsource type=pwl wave=[0 0.9 0.95n 0.9 1n 0 1.75n 0 1.8n 0.9 2.55n 0.9 2.6n 0 3.35n 0 3.4n 0 4.15n 0 4.2n 0.9 4.6n 0.9]
Vd6 (din6 0) vsource type=pwl wave=[0 0.9 0.95n 0.9 1n 0 2.55n 0 2.6n 0.9 3.35n 0.9 3.4n 0 4.15n 0 4.2n 0.9 4.6n 0.9]
Vd7 (din7 0) vsource type=pwl wave=[0 0.9 0.95n 0.9 1n 0 1.75n 0 1.8n 0.9 2.55n 0.9 2.6n 0 3.35n 0 3.4n 0.9 4.6n 0.9]
XDUT (din1 din2 din3 din4 din5 din6 din7 rdy aout) l2_7b_dac_ready

tran tran stop=4.6n maxstep=10p
save aout din1 din2 din3 din4 din5 din6 din7 rdy
