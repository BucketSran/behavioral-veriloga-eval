simulator lang=spectre
global 0

ahdl_include "./dut/cal4bit_modulo.va"

Vain (ain 0) vsource type=pwl wave=[0 -2 0.7n -2 0.75n 1.9 1.4n 1.9 1.45n 7.2 2.1n 7.2 2.15n 18 2.8n 18]
XDUT (ain d0 d1 d2 d3) cal4bit_modulo

tran tran stop=2.6n maxstep=5p
save ain d0 d1 d2 d3
