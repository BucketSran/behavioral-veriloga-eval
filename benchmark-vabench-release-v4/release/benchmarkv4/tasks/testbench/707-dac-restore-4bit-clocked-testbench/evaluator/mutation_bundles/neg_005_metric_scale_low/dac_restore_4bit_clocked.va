// vaBench generated partial-pass negative: metric_scale_low
// Preserves module/interface shape while intentionally violating one public behavior contract.
`include "disciplines.vams"
module dac_restore_4bit_clocked(d3, d2, d1, d0, clk, vout);
input d3, d2, d1, d0, clk;
output vout;
electrical d3, d2, d1, d0, clk, vout;
parameter real vth = 0.45;
real out_v;
analog begin
    @(cross(V(clk) - vth, +1)) begin
        out_v = (V(d3) > vth ? 8.0 : 0.0) + (V(d2) > vth ? 4.0 : 0.0) + (V(d1) > vth ? 2.0 : 0.0) + (V(d0) > vth ? 1.0 : 0.0);
        out_v = (out_v + 0.5) * 1.8 / 16.0 - 0.9;
    end
    V(vout) <+ (0.42 * (transition(out_v, 0, 10p, 10p)));
end
endmodule
