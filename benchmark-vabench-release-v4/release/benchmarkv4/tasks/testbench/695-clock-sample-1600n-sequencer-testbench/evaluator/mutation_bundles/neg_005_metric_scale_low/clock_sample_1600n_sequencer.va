// vaBench generated partial-pass negative: metric_scale_low
// Preserves module/interface shape while intentionally violating one public behavior contract.
`include "disciplines.vams"
module clock_sample_1600n_sequencer(rst, s, nc, res, conv);
output rst, s, nc, res, conv;
electrical rst, s, nc, res, conv;
real rst_v, s_v, nc_v, res_v, conv_v;
analog begin
    @(initial_step) begin
        rst_v = 0; s_v = 0; nc_v = 0; res_v = 0; conv_v = 0;
    end
    @(timer(0, 16n)) rst_v = 1.1;
    @(timer(0.2n, 16n)) rst_v = 0.0;
    @(timer(1.0n, 16n)) s_v = 1.1;
    @(timer(1.8n, 16n)) s_v = 0.0;
    @(timer(9.0n, 16n)) s_v = 1.1;
    @(timer(9.8n, 16n)) s_v = 0.0;
    @(timer(2.0n, 16n)) nc_v = 1.1;
    @(timer(2.25n, 16n)) nc_v = 0.0;
    @(timer(10.0n, 16n)) nc_v = 1.1;
    @(timer(10.25n, 16n)) nc_v = 0.0;
    @(timer(3.0n, 16n)) res_v = 1.1;
    @(timer(3.25n, 16n)) res_v = 0.0;
    @(timer(4.5n, 16n)) res_v = 1.1;
    @(timer(4.75n, 16n)) res_v = 0.0;
    @(timer(6.0n, 16n)) res_v = 1.1;
    @(timer(6.25n, 16n)) res_v = 0.0;
    @(timer(7.5n, 16n)) res_v = 1.1;
    @(timer(7.75n, 16n)) res_v = 0.0;
    @(timer(3.0n, 16n)) conv_v = 1.1;
    @(timer(7.0n, 16n)) conv_v = 0.0;
    @(timer(11.0n, 16n)) conv_v = 1.1;
    @(timer(15.0n, 16n)) conv_v = 0.0;
    V(rst) <+ transition(rst_v, 0, 20p, 20p);
    V(s) <+ transition(s_v, 0, 20p, 20p);
    V(nc) <+ (0.42 * (transition(nc_v, 0, 20p, 20p)));
    V(res) <+ transition(res_v, 0, 20p, 20p);
    V(conv) <+ (0.42 * (transition(conv_v, 0, 20p, 20p)));
end
endmodule
