simulator lang=spectre
global 0

ahdl_include "./dut/event_counter_windowed_16b.va"

Vgate (gate 0) vsource type=pwl wave=[0 0 10n 0 10.1n 0.9 60n 0.9 60.1n 0 90n 0 90.1n 0.9 135n 0.9 135.1n 0 160n 0]
Vevent (event 0) vsource type=pwl wave=[0 0 5n 0 5.1n 0.9 6n 0 15n 0 15.1n 0.9 16n 0 25n 0 25.1n 0.9 26n 0 45n 0 45.1n 0.9 46n 0 62n 0 62.1n 0.9 63n 0 80n 0 80.1n 0.9 81n 0 95n 0 95.1n 0.9 96n 0 105n 0 105.1n 0.9 106n 0 125n 0 125.1n 0.9 126n 0 150n 0]
XDUT (gate event done count0 count1 count2 count3 count4 count5 count6 count7 count8 count9 count10 count11 count12 count13 count14 count15) event_counter_windowed_16b

tran tran stop=160n maxstep=100p
save gate event done count0 count1 count2 count3 count4 count5 count6 count7 count8 count9 count10 count11 count12 count13 count14 count15
