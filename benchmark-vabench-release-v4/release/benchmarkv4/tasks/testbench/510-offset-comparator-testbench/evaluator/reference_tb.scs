simulator lang=spectre
global 0

ahdl_include "./dut/cmp_offset_ref.va"

Vvdd (VDD 0) vsource dc=0.9
Vvss (VSS 0) vsource dc=0.1
Vclk (CLK 0) vsource type=pulse val0=0.1 val1=0.54 delay=1n rise=20p fall=20p width=1n period=4n

// Hidden seven-edge staircase:
// 1n -10mV low, 5n 0mV low, 9n +3mV low,
// 13n +7mV high, 17n +20mV high, 21n 0mV low, 25n -10mV low.
// Steps at 12.2n, 20.2n, and 24.2n verify that the DUT is edge-sampled,
// not an asynchronous comparator.
Vinp (VINP 0) vsource type=pwl wave=[ \
    0      0.540 \
    4.0n   0.540 \
    4.2n   0.550 \
    8.0n   0.550 \
    8.2n   0.553 \
    12.0n  0.553 \
    12.2n  0.557 \
    16.0n  0.557 \
    16.2n  0.570 \
    20.0n  0.570 \
    20.2n  0.550 \
    24.0n  0.550 \
    24.2n  0.540 \
    28.0n  0.540 \
]
Vinn (VINN 0) vsource dc=0.550

XDUT (VDD VSS CLK VINP VINN OUT_P) cmp_offset_ref

tran tran stop=28n maxstep=20p
save VDD VSS CLK VINP VINN OUT_P
