simulator lang=spectre
global 0

ahdl_include "./dut/cyclic_decoder_10b.va"

Vready (ready 0) vsource type=pwl wave=[0 0 1n 0 1.05n 1.1 1.35n 1.1 1.40n 0 2n 0 2.05n 1.1 2.35n 1.1 2.40n 0 3n 0 3.05n 1.1 3.35n 1.1 3.40n 0 4n 0 4.05n 1.1 4.35n 1.1 4.40n 0 5n 0 5.05n 1.1 5.35n 1.1 5.40n 0 6n 0 6.05n 1.1 6.35n 1.1 6.40n 0 7n 0 7.05n 1.1 7.35n 1.1 7.40n 0 8n 0 8.05n 1.1 8.35n 1.1 8.40n 0 9n 0 9.05n 1.1 9.35n 1.1 9.40n 0 10n 0 10.05n 1.1 10.35n 1.1 10.40n 0 16n 0 16.05n 1.1 16.35n 1.1 16.40n 0 17n 0 17.05n 1.1 17.35n 1.1 17.40n 0 18n 0 18.05n 1.1 18.35n 1.1 18.40n 0 19n 0 19.05n 1.1 19.35n 1.1 19.40n 0 20n 0 20.05n 1.1 20.35n 1.1 20.40n 0 21n 0 21.05n 1.1 21.35n 1.1 21.40n 0 22n 0 22.05n 1.1 22.35n 1.1 22.40n 0 23n 0 23.05n 1.1 23.35n 1.1 23.40n 0 24n 0 24.05n 1.1 24.35n 1.1 24.40n 0 25n 0 25.05n 1.1 25.35n 1.1 25.40n 0]
Vdp (dp 0) vsource type=pwl wave=[0 0 0.70n 0 0.75n 1.1 1.70n 1.1 1.75n 0 3.70n 0 3.75n 1.1 4.70n 1.1 4.75n 0 6.70n 0 6.75n 1.1 7.70n 1.1 7.75n 0 9.70n 0 9.75n 1.1 10.70n 1.1 10.75n 0 16.70n 0 16.75n 1.1 17.70n 1.1 17.75n 0 20.70n 0 20.75n 1.1 21.70n 1.1 21.75n 0 23.70n 0 23.75n 1.1 24.70n 1.1 24.75n 0]
Vdn (dn 0) vsource type=pwl wave=[0 0 1.70n 0 1.75n 1.1 2.70n 1.1 2.75n 0 4.70n 0 4.75n 1.1 5.70n 1.1 5.75n 0 7.70n 0 7.75n 1.1 8.70n 1.1 8.75n 0 15.70n 0 15.75n 1.1 16.70n 1.1 16.75n 0 18.70n 0 18.75n 1.1 19.70n 1.1 19.75n 0 21.70n 0 21.75n 1.1 22.70n 1.1 22.75n 0 24.70n 0 24.75n 1.1]
Vclks (clks 0) vsource type=pwl wave=[0 0 13n 0 13.05n 1.1 13.50n 1.1 13.55n 0 28n 0 28.05n 1.1 28.50n 1.1 28.55n 0]

XDUT (dp dn ready clks dout) cyclic_decoder_10b

tran tran stop=32n maxstep=20p
save dp dn ready clks dout
