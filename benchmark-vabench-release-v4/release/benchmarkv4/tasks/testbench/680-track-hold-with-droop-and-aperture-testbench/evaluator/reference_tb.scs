simulator lang=spectre
global 0

ahdl_include "./dut/track_hold_aperture.va"

Vvin (vin 0) vsource type=pwl wave=[0 0.18 5n 0.18 11n 0.78 19n 0.26 27n 0.86 36n 0.16 50n 0.73 67n 0.31 84n 0.65]
Vtrack (track 0) vsource type=pwl wave=[0 0 2n 0 2.1n 0.9 13n 0.9 13.1n 0 22n 0 22.1n 0.9 32n 0.9 32.1n 0 45n 0 45.1n 0.9 58n 0.9 58.1n 0 70n 0 70.1n 0.9 84n 0.9]
Vrst (rst 0) vsource type=pwl wave=[0 0.9 0.8n 0.9 0.9n 0 84n 0]
Ven (enable 0) vsource type=pwl wave=[0 0 1.5n 0 1.6n 0.9 72n 0.9 72.1n 0 76n 0 76.1n 0.9 84n 0.9]

XDUT (vin track rst enable vhold aperture_metric droop_metric valid) track_hold_aperture droop_per_tick=0.018 aperture_gain=0.55

tran tran stop=84n maxstep=80p
save vin track rst enable vhold aperture_metric droop_metric valid
