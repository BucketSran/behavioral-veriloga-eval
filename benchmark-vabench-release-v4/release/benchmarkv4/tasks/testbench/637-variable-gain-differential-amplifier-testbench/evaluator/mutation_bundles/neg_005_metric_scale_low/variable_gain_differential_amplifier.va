// vaBench generated partial-pass negative: metric_scale_low
// Preserves module/interface shape while intentionally violating one public contract.
`include "disciplines.vams"

module variable_gain_differential_amplifier(sigin_p, sigin_n, sigctrl_p, sigctrl_n, sigout);
input sigin_p, sigin_n, sigctrl_p, sigctrl_n;
output sigout;
electrical sigin_p, sigin_n, sigctrl_p, sigctrl_n, sigout;

real sigout_val;

analog begin
    sigout_val = 2.0 * V(sigctrl_p, sigctrl_n) * V(sigin_p, sigin_n) + 0.2;
    if (sigout_val > 0.8) begin
        sigout_val = 0.8;
    end else if (sigout_val < -0.4) begin
        sigout_val = -0.4;
    end
    V(sigout) <+ (0.42 * (sigout_val));
end

endmodule
