simulator lang=spectre
global 0

ahdl_include "./dut/safe_voltage_divider.va"

Vnum (signumer 0) vsource type=pwl wave=[0 0.15 8n 0.15 8.1n -0.30 18n -0.30 18.1n 0.45 30n 0.45 30.1n -0.20 45n -0.20]
Vden (sigdenom 0) vsource type=pwl wave=[0 0.50 8n 0.50 8.1n 0.05 18n 0.05 18.1n -0.05 30n -0.05 30.1n -0.60 45n -0.60]

XDUT (signumer sigdenom sigout) safe_voltage_divider gain=2 min_sigdenom=0.25

tran tran stop=40n maxstep=25p
save sigdenom signumer sigout
