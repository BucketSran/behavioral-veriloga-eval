simulator lang=spectre
global 0

ahdl_include "./dut/pipeline_stage.va"

Vvdd  (vdd  0) vsource dc=0.9
Vvss  (vss  0) vsource dc=0.0
Vvref (vref 0) vsource dc=0.9
Vphi1 (phi1 0) vsource type=pulse val0=0 val1=0.9 period=30n width=10n rise=200p fall=200p delay=3n
Vphi2 (phi2 0) vsource type=pulse val0=0 val1=0.9 period=30n width=10n rise=200p fall=200p delay=15n
Vvin  (vin  0) vsource type=pwl wave=[0 0.45 9n 0.45 9.1n 0.72 39n 0.72 39.1n 0.18 69n 0.18 69.1n 0.90 99n 0.90 99.1n 0.00 129n 0.00 129.1n 0.676 159n 0.676 159.1n 0.674 189n 0.674 189.1n 0.226 219n 0.226 219.1n -0.15 249n -0.15 249.1n 1.05 279n 1.05 279.1n 0.45 300n 0.45]

XDUT (vdd vss phi1 phi2 vin vref vres d1 d0) pipeline_stage vth=0.45 vdd=0.9 tedge=200p

tran tran stop=300n maxstep=500p
save phi1 phi2 vin vref vres d1 d0 vdd vss
