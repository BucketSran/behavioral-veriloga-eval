simulator lang=spectre
global 0

ahdl_include "./dut/charge_pump_pulse_balancer.va"

Vup (up 0) vsource type=pwl wave=[0 0 4.5n 0 4.6n 0.9 44.64n 0.9 44.74n 0 50.64n 0 50.74n 0.9 72n 0.9]
Vdn (dn 0) vsource type=pwl wave=[0 0 4.5n 0 4.6n 0.9 44.64n 0.9 44.74n 0 50.64n 0 50.74n 0.9 72n 0.9]
Vclk (clk 0) vsource type=pulse val0=0 val1=0.9 period=5n width=2.5n delay=1.2n rise=60p fall=60p
Vrst (rst 0) vsource type=pwl wave=[0 0.9 1.7n 0.9 1.8n 0 72n 0]
Venable (enable 0) vsource type=pwl wave=[0 0 4.5n 0 4.6n 0.9 44.64n 0.9 44.74n 0 50.64n 0 50.74n 0.9 72n 0.9]
Vvctrl (vctrl 0) vsource type=pwl wave=[0 0.180 9n 0.180 15n 0.680 28n 0.680 34n 0.420 48n 0.420 72n 0.285]

XDUT (up dn clk rst enable vctrl imbalance_metric balanced) charge_pump_pulse_balancer

tran tran stop=72n maxstep=100p
save up dn clk rst enable vctrl imbalance_metric balanced
