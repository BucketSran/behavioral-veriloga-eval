simulator lang=spectre
global 0

ahdl_include "./dut/divide_by_eight_clock.va"

Vin (vin 0) vsource type=pwl wave=[0 0 1n 0 1.05n 0.9 1.45n 0.9 1.5n 0 3n 0 3.05n 0.9 3.45n 0.9 3.5n 0 5n 0 5.05n 0.9 5.45n 0.9 5.5n 0 7n 0 7.05n 0.9 7.45n 0.9 7.5n 0 9n 0 9.05n 0.9 9.45n 0.9 9.5n 0 11n 0 11.05n 0.9 11.45n 0.9 11.5n 0 13n 0 13.05n 0.9 13.45n 0.9 13.5n 0 15n 0 15.05n 0.9 15.45n 0.9 15.5n 0 17n 0 17.05n 0.9 17.45n 0.9 17.5n 0 19n 0 19.05n 0.9 19.45n 0.9 19.5n 0 21n 0]
Vrst (rst 0) vsource type=pwl wave=[0 0.9 1.25n 0.9 1.30n 0 18.20n 0 18.25n 0.9 18.80n 0.9 18.85n 0]
Ven (en 0) vsource type=pwl wave=[0 0.9 11.60n 0.9 11.65n 0 15.55n 0 15.60n 0.9 24n 0.9]

XDUT (vin rst en vout) divide_by_eight_clock

simulatorOptions options evas_profile=balanced

tran tran stop=18n maxstep=10p
save en rst vin vout
