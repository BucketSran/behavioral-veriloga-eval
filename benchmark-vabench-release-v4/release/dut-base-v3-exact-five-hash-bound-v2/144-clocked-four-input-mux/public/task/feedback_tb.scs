simulator lang=spectre
global 0

ahdl_include "./dut/clocked_four_input_mux.va"

Vclk (clks 0) vsource type=pwl wave=[0 1 2n 1 2.1n 0 4n 0 4.1n 1 12n 1 12.1n 0 14n 0 14.1n 1 22n 1 22.1n 0 24n 0 24.1n 1 32n 1 32.1n 0 34n 0 34.1n 1 38n 1]
Vs0 (dsel0 0) vsource type=pwl wave=[0 0 7n 0 7.1n 1 17n 1 17.1n 0 27n 0 27.1n 1 38n 1]
Vs1 (dsel1 0) vsource type=pwl wave=[0 0 17n 0 17.1n 1 38n 1]
Vd0 (din0 0) vsource dc=0.15
Vd1 (din1 0) vsource dc=0.35
Vd2 (din2 0) vsource dc=0.65
Vd3 (din3 0) vsource dc=0.85

XDUT (dsel0 dsel1 din0 din1 din2 din3 clks dout) clocked_four_input_mux

simulatorOptions options evas_profile=balanced

tran tran stop=36n maxstep=20p
save clks din0 din1 din2 din3 dout dsel0 dsel1
