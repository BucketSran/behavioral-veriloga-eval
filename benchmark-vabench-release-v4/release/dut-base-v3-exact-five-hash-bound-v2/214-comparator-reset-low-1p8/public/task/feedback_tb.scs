simulator lang=spectre
global 0

ahdl_include "./dut/comparator_reset_low_1p8.va"

Vclk (cmpck 0) vsource type=pulse val0=0 val1=1.8 delay=0.35n period=1n width=0.45n rise=20p fall=20p
Vinp (vinp 0) vsource type=pwl wave=[0 1.2 1.0n 1.2 1.05n 0.6 2.0n 0.6 2.05n 1.3 3.2n 1.3]
Vinn (vinn 0) vsource dc=0.9
XDUT (cmpck vinn vinp dcmpn dcmpp) comparator_reset_low_1p8

simulatorOptions options evas_profile=balanced

tran tran stop=3.0n maxstep=5p
save cmpck vinn vinp dcmpn dcmpp
