simulator lang=spectre
global 0

ahdl_include "./dut/va_dac_6b_se.va"

Vrdy (rdy 0) vsource type=pulse val0=0 val1=1 delay=0.2n period=1n width=0.35n rise=20p fall=20p
Vd0 (din0 0) vsource type=pwl wave=[0 0 1.0n 0 1.05n 1 2.0n 1 2.05n 0 3.0n 0 3.05n 1 4n 1]
Vd1 (din1 0) vsource type=pwl wave=[0 0 2.0n 0 2.05n 1 3.0n 1 3.05n 1 4n 1]
Vd2 (din2 0) vsource type=pwl wave=[0 0 2.0n 0 2.05n 0 3.0n 0 3.05n 1 4n 1]
Vd3 (din3 0) vsource type=pwl wave=[0 0 1.0n 0 1.05n 1 2.0n 1 2.05n 0 3.0n 0 3.05n 1 4n 1]
Vd4 (din4 0) vsource type=pwl wave=[0 0 2.0n 0 2.05n 1 3.0n 1 3.05n 1 4n 1]
Vd5 (din5 0) vsource type=pwl wave=[0 0 1.0n 0 1.05n 1 2.0n 1 2.05n 1 3.0n 1 3.05n 1 4n 1]
XDUT (din0 din1 din2 din3 din4 din5 rdy aout) va_dac_6b_se

simulatorOptions options evas_profile=balanced

tran tran stop=2.8n maxstep=10p
save rdy din0 din1 din2 din3 din4 din5 aout
