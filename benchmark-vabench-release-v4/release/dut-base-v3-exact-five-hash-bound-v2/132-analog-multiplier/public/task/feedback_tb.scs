simulator lang=spectre
global 0

ahdl_include "./dut/analog_multiplier_gain.va"

Vin1 (sigin1 0) vsource type=pwl wave=[0 0.2 10n 0.2 10.1n 0.8 20n 0.8 20.1n -0.4 35n -0.4]
Vin2 (sigin2 0) vsource type=pwl wave=[0 0.5 10n 0.5 10.1n 0.3 20n 0.3 20.1n 0.5 35n 0.5]

XDUT (sigin1 sigin2 sigout) analog_multiplier_gain gain=2

simulatorOptions options evas_profile=balanced

tran tran stop=30n maxstep=25p
save sigin1 sigin2 sigout
