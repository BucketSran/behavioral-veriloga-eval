simulator lang=spectre
global 0

ahdl_include "./dut/gain_estimator.va"

Vvdd (vdd 0) vsource type=dc dc=0.9
Vvss (vss 0) vsource type=dc dc=0

Vinp  (vinp  0) vsource type=sine sinedc=0.45 ampl=0.03 freq=20Meg
Vinn  (vinn  0) vsource type=dc dc=0.45
Voutp (voutp 0) vsource type=sine sinedc=0.45 ampl=0.18 freq=20Meg
Voutn (voutn 0) vsource type=dc dc=0.45

XGAIN (vdd vss vinp vinn voutp voutn gain_out valid) gain_estimator \
    sample_period=1n start_time=20n gain_scale=10 min_input_span=0.02 tedge=200p

simulatorOptions options reltol=1e-4 vabstol=1e-6 iabstol=1e-12 temp=27 tnom=27 gmin=1e-12

simulatorOptions options evas_profile=balanced

tran tran stop=240n maxstep=200p errpreset=conservative
save vdd vss vinp vinn voutp voutn gain_out valid
