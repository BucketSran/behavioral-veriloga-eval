simulator lang=spectre
global 0

ahdl_include "./dut/power_mode_supply_current_metric.va"

Vvdd (vdd 0) vsource type=pwl wave=[0 0.9 4n 0.9 4.05n 0.72 8n 0.72 8.05n 1.08 12n 1.08 12.05n 0.9]
Vvss (vss 0) vsource type=pwl wave=[0 0]
Ven (en 0) vsource type=pwl wave=[0 0.9 14n 0.9 14.05n 0]
Vpd (pd 0) vsource type=pwl wave=[0 0 16n 0 16.05n 0.9]
Vmode (mode 0) vsource type=pwl wave=[0 0 6n 0 6.05n 0.9 10n 0.9 10.05n 0]
Vload (load 0) vsource type=pwl wave=[0 0.10 2n 0.10 2.05n 0.70 9n 0.70 9.05n 0.20 13n 0.20 13.05n 0.85]

XDUT (vdd vss en pd mode load isup_metric) power_mode_supply_current_metric

simulatorOptions options evas_profile=balanced

tran tran stop=18n maxstep=10p
save en isup_metric load mode pd vdd vss
