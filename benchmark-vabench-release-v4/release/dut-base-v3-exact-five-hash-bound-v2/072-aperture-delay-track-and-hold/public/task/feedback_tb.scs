simulator lang=spectre
global 0

ahdl_include "./dut/sample_hold_aperture_ref.va"

Vvdd (VDD 0) vsource dc=0.9
Vvss (VSS 0) vsource dc=0.0
Vclk (clk 0) vsource type=pulse val0=0 val1=0.9 delay=5n rise=20p fall=20p width=10n period=20n
Vin  (vin 0) vsource type=pwl wave=[ 0 0.05 5.05n 0.05 5.15n 0.10 24.90n 0.10 25.05n 0.10 25.15n 0.35 44.90n 0.35 45.05n 0.35 45.15n 0.60 64.90n 0.60 65.05n 0.60 65.15n 0.25 84.90n 0.25 85.05n 0.25 85.15n 0.70 104.90n 0.70 105.05n 0.70 105.15n 0.40 124.90n 0.40 125.05n 0.40 125.15n 0.80 140n 0.80 ]

XDUT (VDD VSS clk vin vout) sample_hold_aperture_ref

simulatorOptions options evas_profile=balanced

tran tran stop=100n maxstep=100p
save vin clk vout VDD VSS
