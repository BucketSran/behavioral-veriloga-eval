simulator lang=spectre
global 0

ahdl_include "./dut/offset_gain_amplifier.va"

Vin (sigin 0) vsource type=pwl wave=[0 0.1 10n 0.1 10.1n 0.5 20n 0.5 20.1n -0.1 35n -0.1]

XDUT (sigin sigout) offset_gain_amplifier

simulatorOptions options evas_profile=balanced

tran tran stop=30n maxstep=25p
save sigin sigout
