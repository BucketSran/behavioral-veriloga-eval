simulator lang=spectre
global 0

ahdl_include "./dut/pipe15_data_align.va"

Vsamp (samp 0) vsource type=pwl wave=[0 0 1n 0 1.05n 0.9 1.45n 0.9 1.5n 0 3n 0 3.05n 0.9 3.45n 0.9 3.5n 0 5n 0 5.05n 0.9 5.45n 0.9 5.5n 0 7n 0 7.05n 0.9 7.45n 0.9 7.5n 0 9n 0 9.05n 0.9 9.45n 0.9 9.5n 0 11n 0 11.05n 0.9 11.45n 0.9 11.5n 0]
Vd0 (d0 0) vsource type=pwl wave=[0 0 0.8n 0 0.9n 0.9 2.8n 0.9 2.9n 0 4.8n 0 4.9n 0.9 6.8n 0.9 6.9n 0 8.8n 0 8.9n 0.9 10.8n 0.9 10.9n 0]
Vd1 (d1 0) vsource type=pwl wave=[0 0 0.8n 0 0.9n 0.9 2.8n 0.9 2.9n 0 4.8n 0 4.9n 0.9 6.8n 0.9 6.9n 0 8.8n 0 8.9n 0.9 10.8n 0.9 10.9n 0]
Vd2 (d2 0) vsource type=pwl wave=[0 0 0.8n 0 0.9n 0.9 2.8n 0.9 2.9n 0 4.8n 0 4.9n 0.9 6.8n 0.9 6.9n 0 8.8n 0 8.9n 0.9 10.8n 0.9 10.9n 0]
Vd3 (d3 0) vsource type=pwl wave=[0 0 0.8n 0 0.9n 0.9 2.8n 0.9 2.9n 0 4.8n 0 4.9n 0.9 6.8n 0.9 6.9n 0 8.8n 0 8.9n 0.9 10.8n 0.9 10.9n 0]
Vd4 (d4 0) vsource type=pwl wave=[0 0 0.8n 0 0.9n 0.9 2.8n 0.9 2.9n 0 4.8n 0 4.9n 0.9 6.8n 0.9 6.9n 0 8.8n 0 8.9n 0.9 10.8n 0.9 10.9n 0]
Vd5 (d5 0) vsource type=pwl wave=[0 0 0.8n 0 0.9n 0.9 2.8n 0.9 2.9n 0 4.8n 0 4.9n 0.9 6.8n 0.9 6.9n 0 8.8n 0 8.9n 0.9 10.8n 0.9 10.9n 0]
Vd6 (d6 0) vsource type=pwl wave=[0 0 0.8n 0 0.9n 0.9 2.8n 0.9 2.9n 0 4.8n 0 4.9n 0.9 6.8n 0.9 6.9n 0 8.8n 0 8.9n 0.9 10.8n 0.9 10.9n 0]
Vd7 (d7 0) vsource type=pwl wave=[0 0 0.8n 0 0.9n 0.9 2.8n 0.9 2.9n 0 4.8n 0 4.9n 0.9 6.8n 0.9 6.9n 0 8.8n 0 8.9n 0.9 10.8n 0.9 10.9n 0]
Vd8 (d8 0) vsource type=pwl wave=[0 0 0.8n 0 0.9n 0.9 2.8n 0.9 2.9n 0 4.8n 0 4.9n 0.9 6.8n 0.9 6.9n 0 8.8n 0 8.9n 0.9 10.8n 0.9 10.9n 0]
Vd9 (d9 0) vsource type=pwl wave=[0 0 0.8n 0 0.9n 0.9 2.8n 0.9 2.9n 0 4.8n 0 4.9n 0.9 6.8n 0.9 6.9n 0 8.8n 0 8.9n 0.9 10.8n 0.9 10.9n 0]
Vd10 (d10 0) vsource type=pwl wave=[0 0 0.8n 0 0.9n 0.9 2.8n 0.9 2.9n 0 4.8n 0 4.9n 0.9 6.8n 0.9 6.9n 0 8.8n 0 8.9n 0.9 10.8n 0.9 10.9n 0]
Vd11 (d11 0) vsource type=pwl wave=[0 0 0.8n 0 0.9n 0.9 2.8n 0.9 2.9n 0 4.8n 0 4.9n 0.9 6.8n 0.9 6.9n 0 8.8n 0 8.9n 0.9 10.8n 0.9 10.9n 0]
Vd12 (d12 0) vsource type=pwl wave=[0 0 0.8n 0 0.9n 0.9 2.8n 0.9 2.9n 0 4.8n 0 4.9n 0.9 6.8n 0.9 6.9n 0 8.8n 0 8.9n 0.9 10.8n 0.9 10.9n 0]
Vd13 (d13 0) vsource type=pwl wave=[0 0 0.8n 0 0.9n 0.9 2.8n 0.9 2.9n 0 4.8n 0 4.9n 0.9 6.8n 0.9 6.9n 0 8.8n 0 8.9n 0.9 10.8n 0.9 10.9n 0]
Vd14 (d14 0) vsource type=pwl wave=[0 0 0.8n 0 0.9n 0.9 2.8n 0.9 2.9n 0 4.8n 0 4.9n 0.9 6.8n 0.9 6.9n 0 8.8n 0 8.9n 0.9 10.8n 0.9 10.9n 0]

XDUT (samp d0 d1 d2 d3 d4 d5 d6 d7 d8 d9 d10 d11 d12 d13 d14 do0 do1 do2 do3 do4 do5 do6 do7 do8 do9 do10 do11 do12 do13 do14) pipe15_data_align

simulatorOptions options evas_profile=balanced

tran tran stop=13n maxstep=20p
save d0 d1 d10 d11 d12 d13 d14 d2 d3 d4 d5 d6 d7 d8 d9 do0 do1 do10 do11 do12 do13 do14 do2 do3 do4 do5 do6 do7 do8 do9 samp
