simulator lang=spectre
global 0

ahdl_include "./dut/amplifier_filter_chain.va"

Vclk (clk 0) vsource type=pulse val0=0 val1=0.9 period=2n width=1n rise=50p fall=50p
Vrst (rst 0) vsource type=pwl wave=[0 0.9 2n 0.9 2.1n 0 60n 0]
Vvin (vin 0) vsource type=pwl wave=[0 0.45 8n 0.45 12n 0.9 28n 0.9 31n 0.45 37n 0.45 42n 0.1 58n 0.1 60n 0.45]

XDUT (clk rst vin out metric preamp_mon filt1_mon filt2_mon settle_metric) amplifier_filter_chain

simulatorOptions options evas_profile=balanced

tran tran stop=60n maxstep=0.5n
save clk rst vin out metric preamp_mon filt1_mon filt2_mon settle_metric
