simulator lang=spectre
global 0

ahdl_include "./dut/flash_8level_sum_delay.va"

Vclk (clks 0) vsource type=pwl wave=[0 0 2n 0 2.1n 0.9 2.5n 0.9 2.6n 0 12n 0 12.1n 0.9 12.5n 0.9 12.6n 0 22n 0 22.1n 0.9 22.5n 0.9 22.6n 0 32n 0 32.1n 0.9 32.5n 0.9 32.6n 0 42n 0 42.1n 0.9 42.5n 0.9 42.6n 0 48n 0]
Vvip (vip 0) vsource type=pwl wave=[0 -0.35 8n -0.35 8.1n -0.01 18n -0.01 18.1n 0.24 28n 0.24 28.1n 0.55 38n 0.55 38.1n -0.18 48n -0.18]
Vvim (vim 0) vsource dc=0.05
Vrefp (refp 0) vsource dc=1.2
Vrefn (refn 0) vsource dc=0.2
Vreset (reset 0) vsource dc=0.9

XDUT (vip vim clks reset refp refn doutsum doutsumdelay) flash_8level_sum_delay

tran tran stop=46n maxstep=20p
save clks doutsum doutsumdelay refn refp reset vim vip
