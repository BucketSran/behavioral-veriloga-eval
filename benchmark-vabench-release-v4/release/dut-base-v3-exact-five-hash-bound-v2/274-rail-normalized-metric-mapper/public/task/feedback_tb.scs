simulator lang=spectre
global 0

ahdl_include "./dut/rail_normalized_metric_mapper.va"

Vvss (vss 0) vsource type=pwl wave=[0 0.1 6n 0.1 6.05n -0.08 12n -0.08]
Vvdd (vdd 0) vsource type=pwl wave=[0 0.92 4n 0.92 4.05n 1.28 8n 1.28 8.05n 0.48 10n 0.48 10.05n 0.94 12n 0.94]
Vmeas (meas 0) vsource type=pwl wave=[0 0.47 2n 0.47 2.05n 0.88 4n 0.88 4.05n 0.55 5n 0.55 5.05n 1.4 6n 1.4 6.05n 0.2 8n 0.2 8.05n 0.44 10n 0.44 10.05n -0.12 12n -0.12]
Ven (en 0) vsource type=pwl wave=[0 0.9 6.6n 0.9 6.65n 0 7.8n 0 7.85n 0.9 12n 0.9]

XDUT (meas vdd vss en norm valid) rail_normalized_metric_mapper

simulatorOptions options evas_profile=balanced

tran tran stop=12n maxstep=10p
save meas vdd vss en norm valid time
