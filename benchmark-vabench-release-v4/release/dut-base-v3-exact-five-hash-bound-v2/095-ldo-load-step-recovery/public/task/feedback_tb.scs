simulator lang=spectre
global 0

ahdl_include "./dut/ldo_load_step_recovery_flow.va"

Vclk (clk 0) vsource type=pulse val0=0 val1=0.9 period=2n width=1n rise=50p fall=50p
Vrst (rst 0) vsource type=pwl wave=[0 0.9 2n 0.9 2.1n 0 80n 0]
Vvin (vin 0) vsource type=pwl wave=[0 0.10 15.9n 0.10 16n 0.85 41.9n 0.85 42n 0.20 61.9n 0.20 62n 0.75 80n 0.75]

XDUT (clk rst vin out metric load_mon ctrl_mon) ldo_load_step_recovery_flow

simulatorOptions options evas_profile=balanced

tran tran stop=80n maxstep=0.5n
save clk rst vin out metric load_mon ctrl_mon
