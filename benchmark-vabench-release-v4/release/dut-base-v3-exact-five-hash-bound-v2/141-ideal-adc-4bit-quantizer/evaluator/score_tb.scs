simulator lang=spectre
global 0

ahdl_include "./dut/ideal_adc_4bit_quantizer.va"

Vclk (vclk 0) vsource type=pwl wave=[0 0 1n 0 1.1n 1 3n 1 3.1n 0 11n 0 11.1n 1 13n 1 13.1n 0 21n 0 21.1n 1 23n 1 23.1n 0 31n 0 31.1n 1 33n 1 33.1n 0 41n 0 41.1n 1 43n 1 43.1n 0 48n 0]
Vip (vip 0) vsource type=pwl wave=[0 -0.70 7n -0.70 7.1n -0.08 17n -0.08 17.1n 0.38 27n 0.38 27.1n 0.72 37n 0.72 37.1n 1.10 48n 1.10]
Vin (vin 0) vsource type=pwl wave=[0 0.20 7n 0.20 7.1n 0.15 17n 0.15 17.1n 0.10 27n 0.10 27.1n -0.05 37n -0.05 37.1n 0.00 48n 0.00]

XDUT (vclk vip vin digital) ideal_adc_4bit_quantizer

tran tran stop=46n maxstep=20p
save digital vclk vin vip
