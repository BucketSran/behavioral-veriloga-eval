simulator lang=spectre
global 0

ahdl_include "./dut/dac_mismatch_unit_weighting_model.va"

V_b0 (b0 0) vsource type=pwl wave=[0 0 5n 0 5.1n 0.5 10n 0.5 10.1n 0 20n 0 20.1n 0.5 40n 0.5]
V_b1 (b1 0) vsource type=pwl wave=[0 0 12n 0 12.1n 0.9 40n 0.9]
V_b2 (b2 0) vsource type=pwl wave=[0 0 20n 0 20.1n 0.9 40n 0.9]
V_b3 (b3 0) vsource type=pwl wave=[0 0 30n 0 30.1n 0.9 40n 0.9]

XDUT (b0 b1 b2 b3 out) dac_mismatch_unit_weighting_model

simulatorOptions options evas_profile=balanced

tran tran stop=40n maxstep=0.5n
save b0 b1 b2 b3 out
