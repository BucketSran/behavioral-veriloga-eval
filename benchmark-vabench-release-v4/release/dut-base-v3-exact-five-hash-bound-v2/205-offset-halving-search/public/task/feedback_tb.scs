simulator lang=spectre
global 0

ahdl_include "./dut/offset_halving_search.va"

Vclk (clk 0) vsource type=pulse val0=0 val1=0.9 delay=0.2n period=1n width=0.5n rise=20p fall=20p
Vcmp (dcmpp 0) vsource type=pwl wave=[0 0.9 1.2n 0.9 1.25n 0 2.2n 0 2.25n 0 3.2n 0 3.25n 0.9 4.2n 0.9 4.25n 0 5.2n 0 5.25n 0.9 6.5n 0.9]
XDUT (clk dcmpp vinp vinn) offset_halving_search

simulatorOptions options evas_profile=balanced

tran tran stop=6.2n maxstep=10p
save clk dcmpp vinp vinn
