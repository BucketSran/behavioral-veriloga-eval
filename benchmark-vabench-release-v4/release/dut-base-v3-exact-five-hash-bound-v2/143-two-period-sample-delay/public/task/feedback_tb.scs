simulator lang=spectre
global 0

ahdl_include "./dut/two_period_sample_delay.va"

Vupd (update 0) vsource type=pwl wave=[0 0 2n 0 2.1n 1 3n 1 3.1n 0 12n 0 12.1n 1 13n 1 13.1n 0 22n 0 22.1n 1 23n 1 23.1n 0 32n 0 32.1n 1 33n 1 33.1n 0 42n 0 42.1n 1 43n 1 43.1n 0 48n 0]
Vain (ain 0) vsource type=pwl wave=[0 0.1 7n 0.1 7.1n 0.4 17n 0.4 17.1n 0.8 27n 0.8 27.1n 0.2 37n 0.2 37.1n 0.6 48n 0.6]

XDUT (update ain aout) two_period_sample_delay

simulatorOptions options evas_profile=balanced

tran tran stop=46n maxstep=20p
save ain aout update
