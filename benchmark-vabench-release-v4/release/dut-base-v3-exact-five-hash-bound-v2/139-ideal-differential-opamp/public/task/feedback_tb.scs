simulator lang=spectre
global 0

ahdl_include "./dut/ideal_differential_opamp.va"

VinP (vinp 0) vsource type=pwl wave=[0 0.35 10n 0.35 10.1n 0.45 20n 0.45 20.1n 0.60 30n 0.60 30.1n 0.25 45n 0.25]
VinN (vinn 0) vsource dc=0.45

XDUT (vinp vinn voutp voutn) ideal_differential_opamp

simulatorOptions options evas_profile=balanced

tran tran stop=40n maxstep=25p
save vinn vinp voutn voutp
