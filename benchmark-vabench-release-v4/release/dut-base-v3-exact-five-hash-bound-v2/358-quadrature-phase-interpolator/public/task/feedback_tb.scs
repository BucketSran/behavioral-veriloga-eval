simulator lang=spectre
global 0

ahdl_include "./dut/quadrature_phase_interpolator.va"

Vclk_i (clk_i 0) vsource type=pwl wave=[0 0 9n 0 10n 0.9 12n 0.9 12.2n 0 20n 0.9 22n 0.9 22.2n 0 30n 0.9 32n 0.9 32.2n 0 40n 0.9 42n 0.9 42.2n 0 50n 0.9 52n 0.9 52.2n 0 60n 0.9 62n 0.9 62.2n 0 70n 0.9 72n 0.9 72.2n 0 80n 0.9 82n 0.9 82.2n 0 92n 0]
Vclk_q (clk_q 0) vsource type=pwl wave=[0 0 11.5n 0 12.5n 0.9 14.5n 0.9 14.7n 0 22.5n 0.9 24.5n 0.9 24.7n 0 32.5n 0.9 34.5n 0.9 34.7n 0 42.5n 0.9 44.5n 0.9 44.7n 0 52.5n 0.9 54.5n 0.9 54.7n 0 62.5n 0.9 64.5n 0.9 64.7n 0 72.5n 0.9 74.5n 0.9 74.7n 0 82.5n 0.9 84.5n 0.9 84.7n 0 92n 0]
Vrst (rst 0) vsource type=pwl wave=[0 0.9 3n 0.9 3.2n 0 52n 0 52.2n 0.9 55n 0.9 55.2n 0 92n 0]
Vcode_0 (code_0 0) vsource type=pwl wave=[0 0 8n 0 8.2n 0 18n 0 18.2n 0 28n 0 28.2n 0.9 38n 0.9 38.2n 0.9 48n 0.9 48.2n 0 58n 0 58.2n 0.9 68n 0.9 68.2n 0.9 78n 0.9 78.2n 0.9 92n 0.9]
Vcode_1 (code_1 0) vsource type=pwl wave=[0 0 8n 0 8.2n 0 18n 0 18.2n 0 28n 0 28.2n 0 38n 0 38.2n 0.9 48n 0.9 48.2n 0.9 58n 0.9 58.2n 0.9 68n 0.9 68.2n 0 78n 0 78.2n 0.9 92n 0.9]
Vcode_2 (code_2 0) vsource type=pwl wave=[0 0 8n 0 8.2n 0 18n 0 18.2n 0.9 28n 0.9 28.2n 0 38n 0 38.2n 0.9 48n 0.9 48.2n 0 58n 0 58.2n 0.9 68n 0.9 68.2n 0.9 78n 0.9 78.2n 0.9 92n 0.9]
Vcode_3 (code_3 0) vsource type=pwl wave=[0 0 8n 0 8.2n 0 18n 0 18.2n 0 28n 0 28.2n 0.9 38n 0.9 38.2n 0.9 48n 0.9 48.2n 0 58n 0 58.2n 0 68n 0 68.2n 0.9 78n 0.9 78.2n 0.9 92n 0.9]
Vcode_4 (code_4 0) vsource type=pwl wave=[0 0 8n 0 8.2n 0 18n 0 18.2n 0 28n 0 28.2n 0 38n 0 38.2n 0 48n 0 48.2n 0.9 58n 0.9 58.2n 0.9 68n 0.9 68.2n 0.9 78n 0.9 78.2n 0.9 92n 0.9]
XDUT (clk_i clk_q rst code_4 code_3 code_2 code_1 code_0 clk_out quadrant_1 quadrant_0 phase_metric) quadrature_phase_interpolator

simulatorOptions options evas_profile=balanced

tran tran stop=92n maxstep=200p
save clk_i clk_q rst code_4 code_3 code_2 code_1 code_0 clk_out quadrant_1 quadrant_0 phase_metric
