simulator lang=spectre
global 0

ahdl_include "./dut/linear_pfd_gain.va"

Vin1 (in1 0) vsource type=pwl wave=[0 0.2 7.95n 0.2 8n 0.4 17.95n 0.4 18n 0.1 27.95n 0.1 28n 0.8]
Vin2 (in2 0) vsource type=pwl wave=[0 0.1 7.95n 0.1 8n 0.3 17.95n 0.3 18n 0.5 27.95n 0.5 28n 0.2]

XDUT (in1 in2 out) linear_pfd_gain

simulatorOptions options evas_profile=balanced

tran tran stop=26n maxstep=20p
save in1 in2 out
