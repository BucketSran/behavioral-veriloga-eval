simulator lang=spectre
global 0

ahdl_include "./dut/bias_voltage_generator_with_enable_trim.va"

Vclk (clk 0) vsource type=pulse val0=0 val1=0.9 period=2n width=1n rise=50p fall=50p
Vrst (rst 0) vsource type=pwl wave=[0 0.9 2n 0.9 2.1n 0 80n 0]
Vvin (vin 0) vsource type=pwl wave=[0 0.10 11.9n 0.10 12n 0.35 31.9n 0.35 32n 0.75 53.9n 0.75 54n 0.10 65.9n 0.10 66n 0.55 80n 0.55]

XDUT (clk rst vin out metric) bias_voltage_generator_with_enable_trim

simulatorOptions options evas_profile=balanced

tran tran stop=80n maxstep=0.5n
save clk rst vin out metric
