simulator lang=spectre
global 0

ahdl_include "./dut/fine_coarse_tdc_encoder_top.va"
ahdl_include "./dut/coarse_counter.va"
ahdl_include "./dut/fine_residual_metric.va"

Vstart (start 0) vsource type=pwl wave=[0 0 5n 0 5.1n 0.9 6n 0.9 6.1n 0 27n 0 27.1n 0.9 28n 0.9 28.1n 0 64n 0 64.1n 0.9 65n 0.9 65.1n 0 80n 0]
Vstop (stop 0) vsource type=pwl wave=[0 0 22n 0 22.1n 0.9 23n 0.9 23.1n 0 39n 0 39.1n 0.9 40n 0.9 40.1n 0 78n 0 78.1n 0.9 79n 0.9 79.1n 0 80n 0]
Vref_clk (ref_clk 0) vsource type=pulse val0=0 val1=0.9 period=6n width=3n delay=1n rise=60p fall=60p
Vrst (rst 0) vsource type=pwl wave=[0 0.9 2.1n 0.9 2.2n 0 80n 0]
Venable (enable 0) vsource type=pwl wave=[0 0 5n 0 5.1n 0.9 56n 0.9 56.1n 0 62n 0 62.1n 0.9 80n 0.9]

XDUT (start stop ref_clk rst enable coarse_3 coarse_2 coarse_1 coarse_0 fine_metric valid) fine_coarse_tdc_encoder_top

simulatorOptions options evas_profile=balanced

tran tran stop=80n maxstep=120p
save start stop ref_clk rst enable coarse_3 coarse_2 coarse_1 coarse_0 fine_metric valid
