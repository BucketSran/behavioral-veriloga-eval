simulator lang=spectre
global 0

ahdl_include "./dut/thermometer_dac_15seg.va"

Vref (vref 0) vsource dc=0.9
Vss (vss 0) vsource dc=0

// Programmed unary segment counts at safe sample times:
// 15ns: 0, 45ns: 1, 75ns: 2, 105ns: 7, 135ns: 14, 165ns: 15.
Vseg0  (seg0  0) vsource type=pwl wave=[0 0 29.5n 0 30n 0.9 180n 0.9]
Vseg1  (seg1  0) vsource type=pwl wave=[0 0 59.5n 0 60n 0.9 180n 0.9]
Vseg2  (seg2  0) vsource type=pwl wave=[0 0 89.5n 0 90n 0.9 180n 0.9]
Vseg3  (seg3  0) vsource type=pwl wave=[0 0 89.5n 0 90n 0.9 180n 0.9]
Vseg4  (seg4  0) vsource type=pwl wave=[0 0 89.5n 0 90n 0.9 180n 0.9]
Vseg5  (seg5  0) vsource type=pwl wave=[0 0 89.5n 0 90n 0.9 180n 0.9]
Vseg6  (seg6  0) vsource type=pwl wave=[0 0 89.5n 0 90n 0.9 180n 0.9]
Vseg7  (seg7  0) vsource type=pwl wave=[0 0 119.5n 0 120n 0.9 180n 0.9]
Vseg8  (seg8  0) vsource type=pwl wave=[0 0 119.5n 0 120n 0.9 180n 0.9]
Vseg9  (seg9  0) vsource type=pwl wave=[0 0 119.5n 0 120n 0.9 180n 0.9]
Vseg10 (seg10 0) vsource type=pwl wave=[0 0 119.5n 0 120n 0.9 180n 0.9]
Vseg11 (seg11 0) vsource type=pwl wave=[0 0 119.5n 0 120n 0.9 180n 0.9]
Vseg12 (seg12 0) vsource type=pwl wave=[0 0 119.5n 0 120n 0.9 180n 0.9]
Vseg13 (seg13 0) vsource type=pwl wave=[0 0 119.5n 0 120n 0.9 180n 0.9]
Vseg14 (seg14 0) vsource type=pwl wave=[0 0 149.5n 0 150n 0.9 180n 0.9]

XDUT (seg0 seg1 seg2 seg3 seg4 seg5 seg6 seg7 seg8 seg9 seg10 seg11 seg12 seg13 seg14 vref vss aout) thermometer_dac_15seg

tran tran stop=180n maxstep=500p
save seg0 seg1 seg2 seg3 seg4 seg5 seg6 seg7 seg8 seg9 seg10 seg11 seg12 seg13 seg14 vref vss aout
