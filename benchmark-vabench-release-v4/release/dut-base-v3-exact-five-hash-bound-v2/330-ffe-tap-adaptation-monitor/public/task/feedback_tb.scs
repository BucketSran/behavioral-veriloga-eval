simulator lang=spectre
global 0

ahdl_include "./dut/ffe_tap_adaptation_monitor_top.va"
ahdl_include "./dut/tap_update_controller.va"
ahdl_include "./dut/cursor_metric_core.va"

Verr_in (err_in 0) vsource type=pwl wave=[0 0.300 9n 0.300 15n 0.680 28n 0.680 34n 0.420 48n 0.420 80n 0.315]
Vclk (clk 0) vsource type=pulse val0=0 val1=0.9 period=6n width=3n delay=1n rise=60p fall=60p
Vrst (rst 0) vsource type=pwl wave=[0 0.9 2.1n 0.9 2.2n 0 80n 0]
Venable (enable 0) vsource type=pwl wave=[0 0 5n 0 5.1n 0.9 56n 0.9 56.1n 0 62n 0 62.1n 0.9 80n 0.9]

XDUT (err_in clk rst enable tap_pre tap_post main_out adapt_metric done) ffe_tap_adaptation_monitor_top

simulatorOptions options evas_profile=balanced

tran tran stop=80n maxstep=120p
save err_in clk rst enable tap_pre tap_post main_out adapt_metric done
