simulator lang=spectre
global 0

ahdl_include "./dut/limiting_amplifier_frontend.va"

V_fb_clk (clk 0) vsource type=pulse val0=0 val1=0.9 period=1.7n width=0.76n rise=40p fall=40p
V_fb_rst (rst 0) vsource type=pwl wave=[0 0.9 2.4n 0.9 2.5n 0 61.8n 0 61.9n 0.9 64.2n 0.9 64.3n 0 70n 0]
V_fb_signal (vin 0) vsource type=pwl wave=[0 0.45 7.9n 0.45 8n 0.51 25.9n 0.51 26n 0.76 45.9n 0.76 46n 0.20 63.9n 0.20 64n 0.40 70n 0.40]

XFB_DUT (clk rst vin out metric) limiting_amplifier_frontend

simulatorOptions options evas_profile=balanced

tran tran stop=70n maxstep=0.35n
save clk rst vin out metric
