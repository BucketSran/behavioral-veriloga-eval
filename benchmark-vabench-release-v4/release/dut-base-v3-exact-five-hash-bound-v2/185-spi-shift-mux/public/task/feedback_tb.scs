simulator lang=spectre
global 0

ahdl_include "./dut/spi_shift_mux.va"

Vscki (scki 0) vsource type=pwl wave=[0 0 1n 0 1.05n 0.9 1.45n 0.9 1.50n 0 3n 0 3.05n 0.9 3.45n 0.9 3.50n 0 5n 0 5.05n 0.9 5.45n 0.9 5.50n 0]
Vsdi (sdi 0) vsource type=pwl wave=[0 0.9 2.0n 0.9 2.1n 0 4.0n 0 4.1n 0.9]
Vrst (rst 0) vsource type=pwl wave=[0 0 4.55n 0 4.60n 0.9 4.80n 0.9 4.85n 0]
XDUT (scki sdi rst out0 out1 out2 out3 out4 out5 out6 out7 sdo scko) spi_shift_mux

simulatorOptions options evas_profile=balanced

tran tran stop=4.8n maxstep=20p
save out0 out1 out2 out3 out4 out5 out6 out7 rst scki scko sdi sdo
