simulator lang=spectre
global 0

ahdl_include "./dut/capacitive_feedback_amplifier_macro.va"

Vvin (vin 0) vsource type=pwl wave=[0 0.32 12n 0.32 25n 0.68 42n 0.68 58n 0.26 90n 0.56]
Vclk (clk 0) vsource type=pulse val0=0 val1=0.9 period=6n width=3.0n delay=1n rise=60p fall=60p
Vrst (rst 0) vsource type=pwl wave=[0 0.9 2n 0.9 2.1n 0 90n 0]
Venable (enable 0) vsource type=pwl wave=[0 0 4n 0 4.1n 0.9 55n 0.9 55.1n 0 62n 0 62.1n 0.9 90n 0.9]
Vgain_1 (gain_1 0) vsource type=pwl wave=[0 0 18n 0 18.1n 0.9 46n 0.9 46.1n 0 90n 0]
Vgain_0 (gain_0 0) vsource type=pwl wave=[0 0 30n 0 30.1n 0.9 64n 0.9 64.1n 0 90n 0]

XDUT (vin clk rst enable gain_1 gain_0 vout sampled_metric settled) capacitive_feedback_amplifier_macro

simulatorOptions options evas_profile=balanced

tran tran stop=90n maxstep=80p
save vin clk rst enable gain_1 gain_0 vout sampled_metric settled
