simulator lang=spectre
global 0

ahdl_include "./dut/bandgap_reference_macro_model.va"

V_fb_clk (clk 0) vsource type=pulse val0=0 val1=0.9 period=1.6n width=0.72n rise=40p fall=40p
V_fb_rst (rst 0) vsource type=pwl wave=[0 0.9 2.4n 0.9 2.5n 0 76n 0]
V_fb_supply (vin 0) vsource type=pwl wave=[0 0.30 9.9n 0.30 10n 0.68 42.9n 0.68 43n 0.82 64.9n 0.82 65n 0.52 70.9n 0.52 71n 0.73 76n 0.73]

XFB_DUT (clk rst vin out metric) bandgap_reference_macro_model

simulatorOptions options evas_profile=balanced

tran tran stop=76n maxstep=0.4n
save clk rst vin out metric
