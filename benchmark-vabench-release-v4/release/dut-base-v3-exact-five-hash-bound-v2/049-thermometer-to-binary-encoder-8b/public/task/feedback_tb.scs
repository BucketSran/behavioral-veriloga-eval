simulator lang=spectre
global 0

ahdl_include "./dut/therm_to_bin_8b.va"

Vth0 (th0 0) vsource type=pwl wave=[0 0 9.5n 0 10n 0.9 19.5n 0.9 20n 0.9 29.5n 0.9 30n 0.9 39.5n 0.9 40n 0.9 49.5n 0.9 50n 0.9 59.5n 0.9 60n 0.9 69.5n 0.9 70n 0.9 79.5n 0.9 80n 0.9 89.5n 0.9 90n 0.9 99.5n 0.9 100n 0.9 109.5n 0.9 110n 0.9 119.5n 0.9 120n 0.9 129.5n 0.9 130n 0.9 139.5n 0.9]
Vth1 (th1 0) vsource type=pwl wave=[0 0 9.5n 0 10n 0 19.5n 0 20n 0.9 29.5n 0.9 30n 0.9 39.5n 0.9 40n 0.9 49.5n 0.9 50n 0.9 59.5n 0.9 60n 0.9 69.5n 0.9 70n 0.9 79.5n 0.9 80n 0.9 89.5n 0.9 90n 0.9 99.5n 0.9 100n 0.9 109.5n 0.9 110n 0.9 119.5n 0.9 120n 0.9 129.5n 0.9 130n 0 139.5n 0]
Vth2 (th2 0) vsource type=pwl wave=[0 0 9.5n 0 10n 0 19.5n 0 20n 0 29.5n 0 30n 0.9 39.5n 0.9 40n 0.9 49.5n 0.9 50n 0.9 59.5n 0.9 60n 0.9 69.5n 0.9 70n 0.9 79.5n 0.9 80n 0.9 89.5n 0.9 90n 0.9 99.5n 0.9 100n 0.9 109.5n 0.9 110n 0.9 119.5n 0.9 120n 0.9 129.5n 0.9 130n 0.9 139.5n 0.9]
Vth3 (th3 0) vsource type=pwl wave=[0 0 9.5n 0 10n 0 19.5n 0 20n 0 29.5n 0 30n 0 39.5n 0 40n 0.9 49.5n 0.9 50n 0.9 59.5n 0.9 60n 0.9 69.5n 0.9 70n 0.9 79.5n 0.9 80n 0.9 89.5n 0.9 90n 0.9 99.5n 0.9 100n 0.9 109.5n 0.9 110n 0.9 119.5n 0.9 120n 0.9 129.5n 0.9 130n 0.9 139.5n 0.9]
Vth4 (th4 0) vsource type=pwl wave=[0 0 9.5n 0 10n 0 19.5n 0 20n 0 29.5n 0 30n 0 39.5n 0 40n 0.9 49.5n 0.9 50n 0.9 59.5n 0.9 60n 0.9 69.5n 0.9 70n 0.9 79.5n 0.9 80n 0.9 89.5n 0.9 90n 0.9 99.5n 0.9 100n 0.9 109.5n 0.9 110n 0.9 119.5n 0.9 120n 0.9 129.5n 0.9 130n 0 139.5n 0]
Vth5 (th5 0) vsource type=pwl wave=[0 0 9.5n 0 10n 0 19.5n 0 20n 0 29.5n 0 30n 0 39.5n 0 40n 0.9 49.5n 0.9 50n 0.9 59.5n 0.9 60n 0.9 69.5n 0.9 70n 0.9 79.5n 0.9 80n 0.9 89.5n 0.9 90n 0.9 99.5n 0.9 100n 0.9 109.5n 0.9 110n 0.9 119.5n 0.9 120n 0.9 129.5n 0.9 130n 0 139.5n 0]
Vth6 (th6 0) vsource type=pwl wave=[0 0 9.5n 0 10n 0 19.5n 0 20n 0 29.5n 0 30n 0 39.5n 0 40n 0.9 49.5n 0.9 50n 0.9 59.5n 0.9 60n 0.9 69.5n 0.9 70n 0.9 79.5n 0.9 80n 0.9 89.5n 0.9 90n 0.9 99.5n 0.9 100n 0.9 109.5n 0.9 110n 0.9 119.5n 0.9 120n 0.9 129.5n 0.9 130n 0 139.5n 0]
Vth7 (th7 0) vsource type=pwl wave=[0 0 9.5n 0 10n 0 19.5n 0 20n 0 29.5n 0 30n 0 39.5n 0 40n 0 49.5n 0 50n 0.9 59.5n 0.9 60n 0.9 69.5n 0.9 70n 0.9 79.5n 0.9 80n 0.9 89.5n 0.9 90n 0.9 99.5n 0.9 100n 0.9 109.5n 0.9 110n 0.9 119.5n 0.9 120n 0.9 129.5n 0.9 130n 0 139.5n 0]
Vth8 (th8 0) vsource type=pwl wave=[0 0 9.5n 0 10n 0 19.5n 0 20n 0 29.5n 0 30n 0 39.5n 0 40n 0 49.5n 0 50n 0.9 59.5n 0.9 60n 0.9 69.5n 0.9 70n 0.9 79.5n 0.9 80n 0.9 89.5n 0.9 90n 0.9 99.5n 0.9 100n 0.9 109.5n 0.9 110n 0.9 119.5n 0.9 120n 0.9 129.5n 0.9 130n 0 139.5n 0]
Vth9 (th9 0) vsource type=pwl wave=[0 0 9.5n 0 10n 0 19.5n 0 20n 0 29.5n 0 30n 0 39.5n 0 40n 0 49.5n 0 50n 0.9 59.5n 0.9 60n 0.9 69.5n 0.9 70n 0.9 79.5n 0.9 80n 0.9 89.5n 0.9 90n 0.9 99.5n 0.9 100n 0.9 109.5n 0.9 110n 0.9 119.5n 0.9 120n 0.9 129.5n 0.9 130n 0 139.5n 0]
Vth10 (th10 0) vsource type=pwl wave=[0 0 9.5n 0 10n 0 19.5n 0 20n 0 29.5n 0 30n 0 39.5n 0 40n 0 49.5n 0 50n 0.9 59.5n 0.9 60n 0.9 69.5n 0.9 70n 0.9 79.5n 0.9 80n 0.9 89.5n 0.9 90n 0.9 99.5n 0.9 100n 0.9 109.5n 0.9 110n 0.9 119.5n 0.9 120n 0.9 129.5n 0.9 130n 0 139.5n 0]
Vth11 (th11 0) vsource type=pwl wave=[0 0 9.5n 0 10n 0 19.5n 0 20n 0 29.5n 0 30n 0 39.5n 0 40n 0 49.5n 0 50n 0.9 59.5n 0.9 60n 0.9 69.5n 0.9 70n 0.9 79.5n 0.9 80n 0.9 89.5n 0.9 90n 0.9 99.5n 0.9 100n 0.9 109.5n 0.9 110n 0.9 119.5n 0.9 120n 0.9 129.5n 0.9 130n 0 139.5n 0]
Vth12 (th12 0) vsource type=pwl wave=[0 0 9.5n 0 10n 0 19.5n 0 20n 0 29.5n 0 30n 0 39.5n 0 40n 0 49.5n 0 50n 0.9 59.5n 0.9 60n 0.9 69.5n 0.9 70n 0.9 79.5n 0.9 80n 0.9 89.5n 0.9 90n 0.9 99.5n 0.9 100n 0.9 109.5n 0.9 110n 0.9 119.5n 0.9 120n 0.9 129.5n 0.9 130n 0 139.5n 0]
Vth13 (th13 0) vsource type=pwl wave=[0 0 9.5n 0 10n 0 19.5n 0 20n 0 29.5n 0 30n 0 39.5n 0 40n 0 49.5n 0 50n 0.9 59.5n 0.9 60n 0.9 69.5n 0.9 70n 0.9 79.5n 0.9 80n 0.9 89.5n 0.9 90n 0.9 99.5n 0.9 100n 0.9 109.5n 0.9 110n 0.9 119.5n 0.9 120n 0.9 129.5n 0.9 130n 0 139.5n 0]
Vth14 (th14 0) vsource type=pwl wave=[0 0 9.5n 0 10n 0 19.5n 0 20n 0 29.5n 0 30n 0 39.5n 0 40n 0 49.5n 0 50n 0.9 59.5n 0.9 60n 0.9 69.5n 0.9 70n 0.9 79.5n 0.9 80n 0.9 89.5n 0.9 90n 0.9 99.5n 0.9 100n 0.9 109.5n 0.9 110n 0.9 119.5n 0.9 120n 0.9 129.5n 0.9 130n 0 139.5n 0]
Vth15 (th15 0) vsource type=pwl wave=[0 0 9.5n 0 10n 0 19.5n 0 20n 0 29.5n 0 30n 0 39.5n 0 40n 0 49.5n 0 50n 0 59.5n 0 60n 0.9 69.5n 0.9 70n 0.9 79.5n 0.9 80n 0.9 89.5n 0.9 90n 0.9 99.5n 0.9 100n 0.9 109.5n 0.9 110n 0.9 119.5n 0.9 120n 0.9 129.5n 0.9 130n 0 139.5n 0]
Vth16 (th16 0) vsource type=pwl wave=[0 0 9.5n 0 10n 0 19.5n 0 20n 0 29.5n 0 30n 0 39.5n 0 40n 0 49.5n 0 50n 0 59.5n 0 60n 0 69.5n 0 70n 0.9 79.5n 0.9 80n 0.9 89.5n 0.9 90n 0.9 99.5n 0.9 100n 0.9 109.5n 0.9 110n 0.9 119.5n 0.9 120n 0.9 129.5n 0.9 130n 0 139.5n 0]
Vth17 (th17 0) vsource type=pwl wave=[0 0 9.5n 0 10n 0 19.5n 0 20n 0 29.5n 0 30n 0 39.5n 0 40n 0 49.5n 0 50n 0 59.5n 0 60n 0 69.5n 0 70n 0.9 79.5n 0.9 80n 0.9 89.5n 0.9 90n 0.9 99.5n 0.9 100n 0.9 109.5n 0.9 110n 0.9 119.5n 0.9 120n 0.9 129.5n 0.9 130n 0 139.5n 0]
Vth18 (th18 0) vsource type=pwl wave=[0 0 9.5n 0 10n 0 19.5n 0 20n 0 29.5n 0 30n 0 39.5n 0 40n 0 49.5n 0 50n 0 59.5n 0 60n 0 69.5n 0 70n 0.9 79.5n 0.9 80n 0.9 89.5n 0.9 90n 0.9 99.5n 0.9 100n 0.9 109.5n 0.9 110n 0.9 119.5n 0.9 120n 0.9 129.5n 0.9 130n 0 139.5n 0]
Vth19 (th19 0) vsource type=pwl wave=[0 0 9.5n 0 10n 0 19.5n 0 20n 0 29.5n 0 30n 0 39.5n 0 40n 0 49.5n 0 50n 0 59.5n 0 60n 0 69.5n 0 70n 0.9 79.5n 0.9 80n 0.9 89.5n 0.9 90n 0.9 99.5n 0.9 100n 0.9 109.5n 0.9 110n 0.9 119.5n 0.9 120n 0.9 129.5n 0.9 130n 0 139.5n 0]
Vth20 (th20 0) vsource type=pwl wave=[0 0 9.5n 0 10n 0 19.5n 0 20n 0 29.5n 0 30n 0 39.5n 0 40n 0 49.5n 0 50n 0 59.5n 0 60n 0 69.5n 0 70n 0.9 79.5n 0.9 80n 0.9 89.5n 0.9 90n 0.9 99.5n 0.9 100n 0.9 109.5n 0.9 110n 0.9 119.5n 0.9 120n 0.9 129.5n 0.9 130n 0 139.5n 0]
Vth21 (th21 0) vsource type=pwl wave=[0 0 9.5n 0 10n 0 19.5n 0 20n 0 29.5n 0 30n 0 39.5n 0 40n 0 49.5n 0 50n 0 59.5n 0 60n 0 69.5n 0 70n 0.9 79.5n 0.9 80n 0.9 89.5n 0.9 90n 0.9 99.5n 0.9 100n 0.9 109.5n 0.9 110n 0.9 119.5n 0.9 120n 0.9 129.5n 0.9 130n 0 139.5n 0]
Vth22 (th22 0) vsource type=pwl wave=[0 0 9.5n 0 10n 0 19.5n 0 20n 0 29.5n 0 30n 0 39.5n 0 40n 0 49.5n 0 50n 0 59.5n 0 60n 0 69.5n 0 70n 0.9 79.5n 0.9 80n 0.9 89.5n 0.9 90n 0.9 99.5n 0.9 100n 0.9 109.5n 0.9 110n 0.9 119.5n 0.9 120n 0.9 129.5n 0.9 130n 0 139.5n 0]
Vth23 (th23 0) vsource type=pwl wave=[0 0 9.5n 0 10n 0 19.5n 0 20n 0 29.5n 0 30n 0 39.5n 0 40n 0 49.5n 0 50n 0 59.5n 0 60n 0 69.5n 0 70n 0.9 79.5n 0.9 80n 0.9 89.5n 0.9 90n 0.9 99.5n 0.9 100n 0.9 109.5n 0.9 110n 0.9 119.5n 0.9 120n 0.9 129.5n 0.9 130n 0 139.5n 0]
Vth24 (th24 0) vsource type=pwl wave=[0 0 9.5n 0 10n 0 19.5n 0 20n 0 29.5n 0 30n 0 39.5n 0 40n 0 49.5n 0 50n 0 59.5n 0 60n 0 69.5n 0 70n 0.9 79.5n 0.9 80n 0.9 89.5n 0.9 90n 0.9 99.5n 0.9 100n 0.9 109.5n 0.9 110n 0.9 119.5n 0.9 120n 0.9 129.5n 0.9 130n 0 139.5n 0]
Vth25 (th25 0) vsource type=pwl wave=[0 0 9.5n 0 10n 0 19.5n 0 20n 0 29.5n 0 30n 0 39.5n 0 40n 0 49.5n 0 50n 0 59.5n 0 60n 0 69.5n 0 70n 0.9 79.5n 0.9 80n 0.9 89.5n 0.9 90n 0.9 99.5n 0.9 100n 0.9 109.5n 0.9 110n 0.9 119.5n 0.9 120n 0.9 129.5n 0.9 130n 0 139.5n 0]
Vth26 (th26 0) vsource type=pwl wave=[0 0 9.5n 0 10n 0 19.5n 0 20n 0 29.5n 0 30n 0 39.5n 0 40n 0 49.5n 0 50n 0 59.5n 0 60n 0 69.5n 0 70n 0.9 79.5n 0.9 80n 0.9 89.5n 0.9 90n 0.9 99.5n 0.9 100n 0.9 109.5n 0.9 110n 0.9 119.5n 0.9 120n 0.9 129.5n 0.9 130n 0 139.5n 0]
Vth27 (th27 0) vsource type=pwl wave=[0 0 9.5n 0 10n 0 19.5n 0 20n 0 29.5n 0 30n 0 39.5n 0 40n 0 49.5n 0 50n 0 59.5n 0 60n 0 69.5n 0 70n 0.9 79.5n 0.9 80n 0.9 89.5n 0.9 90n 0.9 99.5n 0.9 100n 0.9 109.5n 0.9 110n 0.9 119.5n 0.9 120n 0.9 129.5n 0.9 130n 0 139.5n 0]
Vth28 (th28 0) vsource type=pwl wave=[0 0 9.5n 0 10n 0 19.5n 0 20n 0 29.5n 0 30n 0 39.5n 0 40n 0 49.5n 0 50n 0 59.5n 0 60n 0 69.5n 0 70n 0.9 79.5n 0.9 80n 0.9 89.5n 0.9 90n 0.9 99.5n 0.9 100n 0.9 109.5n 0.9 110n 0.9 119.5n 0.9 120n 0.9 129.5n 0.9 130n 0 139.5n 0]
Vth29 (th29 0) vsource type=pwl wave=[0 0 9.5n 0 10n 0 19.5n 0 20n 0 29.5n 0 30n 0 39.5n 0 40n 0 49.5n 0 50n 0 59.5n 0 60n 0 69.5n 0 70n 0.9 79.5n 0.9 80n 0.9 89.5n 0.9 90n 0.9 99.5n 0.9 100n 0.9 109.5n 0.9 110n 0.9 119.5n 0.9 120n 0.9 129.5n 0.9 130n 0 139.5n 0]
Vth30 (th30 0) vsource type=pwl wave=[0 0 9.5n 0 10n 0 19.5n 0 20n 0 29.5n 0 30n 0 39.5n 0 40n 0 49.5n 0 50n 0 59.5n 0 60n 0 69.5n 0 70n 0.9 79.5n 0.9 80n 0.9 89.5n 0.9 90n 0.9 99.5n 0.9 100n 0.9 109.5n 0.9 110n 0.9 119.5n 0.9 120n 0.9 129.5n 0.9 130n 0 139.5n 0]
Vth31 (th31 0) vsource type=pwl wave=[0 0 9.5n 0 10n 0 19.5n 0 20n 0 29.5n 0 30n 0 39.5n 0 40n 0 49.5n 0 50n 0 59.5n 0 60n 0 69.5n 0 70n 0 79.5n 0 80n 0.9 89.5n 0.9 90n 0.9 99.5n 0.9 100n 0.9 109.5n 0.9 110n 0.9 119.5n 0.9 120n 0.9 129.5n 0.9 130n 0 139.5n 0]
Vth32 (th32 0) vsource type=pwl wave=[0 0 9.5n 0 10n 0 19.5n 0 20n 0 29.5n 0 30n 0 39.5n 0 40n 0 49.5n 0 50n 0 59.5n 0 60n 0 69.5n 0 70n 0 79.5n 0 80n 0.9 89.5n 0.9 90n 0.9 99.5n 0.9 100n 0.9 109.5n 0.9 110n 0.9 119.5n 0.9 120n 0.9 129.5n 0.9 130n 0 139.5n 0]
Vth33 (th33 0) vsource type=pwl wave=[0 0 9.5n 0 10n 0 19.5n 0 20n 0 29.5n 0 30n 0 39.5n 0 40n 0 49.5n 0 50n 0 59.5n 0 60n 0 69.5n 0 70n 0 79.5n 0 80n 0.9 89.5n 0.9 90n 0.9 99.5n 0.9 100n 0.9 109.5n 0.9 110n 0.9 119.5n 0.9 120n 0.9 129.5n 0.9 130n 0 139.5n 0]
Vth34 (th34 0) vsource type=pwl wave=[0 0 9.5n 0 10n 0 19.5n 0 20n 0 29.5n 0 30n 0 39.5n 0 40n 0 49.5n 0 50n 0 59.5n 0 60n 0 69.5n 0 70n 0 79.5n 0 80n 0.9 89.5n 0.9 90n 0.9 99.5n 0.9 100n 0.9 109.5n 0.9 110n 0.9 119.5n 0.9 120n 0.9 129.5n 0.9 130n 0 139.5n 0]
Vth35 (th35 0) vsource type=pwl wave=[0 0 9.5n 0 10n 0 19.5n 0 20n 0 29.5n 0 30n 0 39.5n 0 40n 0 49.5n 0 50n 0 59.5n 0 60n 0 69.5n 0 70n 0 79.5n 0 80n 0.9 89.5n 0.9 90n 0.9 99.5n 0.9 100n 0.9 109.5n 0.9 110n 0.9 119.5n 0.9 120n 0.9 129.5n 0.9 130n 0 139.5n 0]
Vth36 (th36 0) vsource type=pwl wave=[0 0 9.5n 0 10n 0 19.5n 0 20n 0 29.5n 0 30n 0 39.5n 0 40n 0 49.5n 0 50n 0 59.5n 0 60n 0 69.5n 0 70n 0 79.5n 0 80n 0.9 89.5n 0.9 90n 0.9 99.5n 0.9 100n 0.9 109.5n 0.9 110n 0.9 119.5n 0.9 120n 0.9 129.5n 0.9 130n 0 139.5n 0]
Vth37 (th37 0) vsource type=pwl wave=[0 0 9.5n 0 10n 0 19.5n 0 20n 0 29.5n 0 30n 0 39.5n 0 40n 0 49.5n 0 50n 0 59.5n 0 60n 0 69.5n 0 70n 0 79.5n 0 80n 0.9 89.5n 0.9 90n 0.9 99.5n 0.9 100n 0.9 109.5n 0.9 110n 0.9 119.5n 0.9 120n 0.9 129.5n 0.9 130n 0 139.5n 0]
Vth38 (th38 0) vsource type=pwl wave=[0 0 9.5n 0 10n 0 19.5n 0 20n 0 29.5n 0 30n 0 39.5n 0 40n 0 49.5n 0 50n 0 59.5n 0 60n 0 69.5n 0 70n 0 79.5n 0 80n 0.9 89.5n 0.9 90n 0.9 99.5n 0.9 100n 0.9 109.5n 0.9 110n 0.9 119.5n 0.9 120n 0.9 129.5n 0.9 130n 0 139.5n 0]
Vth39 (th39 0) vsource type=pwl wave=[0 0 9.5n 0 10n 0 19.5n 0 20n 0 29.5n 0 30n 0 39.5n 0 40n 0 49.5n 0 50n 0 59.5n 0 60n 0 69.5n 0 70n 0 79.5n 0 80n 0.9 89.5n 0.9 90n 0.9 99.5n 0.9 100n 0.9 109.5n 0.9 110n 0.9 119.5n 0.9 120n 0.9 129.5n 0.9 130n 0 139.5n 0]
Vth40 (th40 0) vsource type=pwl wave=[0 0 9.5n 0 10n 0 19.5n 0 20n 0 29.5n 0 30n 0 39.5n 0 40n 0 49.5n 0 50n 0 59.5n 0 60n 0 69.5n 0 70n 0 79.5n 0 80n 0.9 89.5n 0.9 90n 0.9 99.5n 0.9 100n 0.9 109.5n 0.9 110n 0.9 119.5n 0.9 120n 0.9 129.5n 0.9 130n 0 139.5n 0]
Vth41 (th41 0) vsource type=pwl wave=[0 0 9.5n 0 10n 0 19.5n 0 20n 0 29.5n 0 30n 0 39.5n 0 40n 0 49.5n 0 50n 0 59.5n 0 60n 0 69.5n 0 70n 0 79.5n 0 80n 0.9 89.5n 0.9 90n 0.9 99.5n 0.9 100n 0.9 109.5n 0.9 110n 0.9 119.5n 0.9 120n 0.9 129.5n 0.9 130n 0 139.5n 0]
Vth42 (th42 0) vsource type=pwl wave=[0 0 9.5n 0 10n 0 19.5n 0 20n 0 29.5n 0 30n 0 39.5n 0 40n 0 49.5n 0 50n 0 59.5n 0 60n 0 69.5n 0 70n 0 79.5n 0 80n 0.9 89.5n 0.9 90n 0.9 99.5n 0.9 100n 0.9 109.5n 0.9 110n 0.9 119.5n 0.9 120n 0.9 129.5n 0.9 130n 0 139.5n 0]
Vth43 (th43 0) vsource type=pwl wave=[0 0 9.5n 0 10n 0 19.5n 0 20n 0 29.5n 0 30n 0 39.5n 0 40n 0 49.5n 0 50n 0 59.5n 0 60n 0 69.5n 0 70n 0 79.5n 0 80n 0.9 89.5n 0.9 90n 0.9 99.5n 0.9 100n 0.9 109.5n 0.9 110n 0.9 119.5n 0.9 120n 0.9 129.5n 0.9 130n 0 139.5n 0]
Vth44 (th44 0) vsource type=pwl wave=[0 0 9.5n 0 10n 0 19.5n 0 20n 0 29.5n 0 30n 0 39.5n 0 40n 0 49.5n 0 50n 0 59.5n 0 60n 0 69.5n 0 70n 0 79.5n 0 80n 0.9 89.5n 0.9 90n 0.9 99.5n 0.9 100n 0.9 109.5n 0.9 110n 0.9 119.5n 0.9 120n 0.9 129.5n 0.9 130n 0 139.5n 0]
Vth45 (th45 0) vsource type=pwl wave=[0 0 9.5n 0 10n 0 19.5n 0 20n 0 29.5n 0 30n 0 39.5n 0 40n 0 49.5n 0 50n 0 59.5n 0 60n 0 69.5n 0 70n 0 79.5n 0 80n 0.9 89.5n 0.9 90n 0.9 99.5n 0.9 100n 0.9 109.5n 0.9 110n 0.9 119.5n 0.9 120n 0.9 129.5n 0.9 130n 0 139.5n 0]
Vth46 (th46 0) vsource type=pwl wave=[0 0 9.5n 0 10n 0 19.5n 0 20n 0 29.5n 0 30n 0 39.5n 0 40n 0 49.5n 0 50n 0 59.5n 0 60n 0 69.5n 0 70n 0 79.5n 0 80n 0.9 89.5n 0.9 90n 0.9 99.5n 0.9 100n 0.9 109.5n 0.9 110n 0.9 119.5n 0.9 120n 0.9 129.5n 0.9 130n 0 139.5n 0]
Vth47 (th47 0) vsource type=pwl wave=[0 0 9.5n 0 10n 0 19.5n 0 20n 0 29.5n 0 30n 0 39.5n 0 40n 0 49.5n 0 50n 0 59.5n 0 60n 0 69.5n 0 70n 0 79.5n 0 80n 0.9 89.5n 0.9 90n 0.9 99.5n 0.9 100n 0.9 109.5n 0.9 110n 0.9 119.5n 0.9 120n 0.9 129.5n 0.9 130n 0 139.5n 0]
Vth48 (th48 0) vsource type=pwl wave=[0 0 9.5n 0 10n 0 19.5n 0 20n 0 29.5n 0 30n 0 39.5n 0 40n 0 49.5n 0 50n 0 59.5n 0 60n 0 69.5n 0 70n 0 79.5n 0 80n 0.9 89.5n 0.9 90n 0.9 99.5n 0.9 100n 0.9 109.5n 0.9 110n 0.9 119.5n 0.9 120n 0.9 129.5n 0.9 130n 0 139.5n 0]
Vth49 (th49 0) vsource type=pwl wave=[0 0 9.5n 0 10n 0 19.5n 0 20n 0 29.5n 0 30n 0 39.5n 0 40n 0 49.5n 0 50n 0 59.5n 0 60n 0 69.5n 0 70n 0 79.5n 0 80n 0.9 89.5n 0.9 90n 0.9 99.5n 0.9 100n 0.9 109.5n 0.9 110n 0.9 119.5n 0.9 120n 0.9 129.5n 0.9 130n 0 139.5n 0]
Vth50 (th50 0) vsource type=pwl wave=[0 0 9.5n 0 10n 0 19.5n 0 20n 0 29.5n 0 30n 0 39.5n 0 40n 0 49.5n 0 50n 0 59.5n 0 60n 0 69.5n 0 70n 0 79.5n 0 80n 0.9 89.5n 0.9 90n 0.9 99.5n 0.9 100n 0.9 109.5n 0.9 110n 0.9 119.5n 0.9 120n 0.9 129.5n 0.9 130n 0 139.5n 0]
Vth51 (th51 0) vsource type=pwl wave=[0 0 9.5n 0 10n 0 19.5n 0 20n 0 29.5n 0 30n 0 39.5n 0 40n 0 49.5n 0 50n 0 59.5n 0 60n 0 69.5n 0 70n 0 79.5n 0 80n 0.9 89.5n 0.9 90n 0.9 99.5n 0.9 100n 0.9 109.5n 0.9 110n 0.9 119.5n 0.9 120n 0.9 129.5n 0.9 130n 0 139.5n 0]
Vth52 (th52 0) vsource type=pwl wave=[0 0 9.5n 0 10n 0 19.5n 0 20n 0 29.5n 0 30n 0 39.5n 0 40n 0 49.5n 0 50n 0 59.5n 0 60n 0 69.5n 0 70n 0 79.5n 0 80n 0.9 89.5n 0.9 90n 0.9 99.5n 0.9 100n 0.9 109.5n 0.9 110n 0.9 119.5n 0.9 120n 0.9 129.5n 0.9 130n 0 139.5n 0]
Vth53 (th53 0) vsource type=pwl wave=[0 0 9.5n 0 10n 0 19.5n 0 20n 0 29.5n 0 30n 0 39.5n 0 40n 0 49.5n 0 50n 0 59.5n 0 60n 0 69.5n 0 70n 0 79.5n 0 80n 0.9 89.5n 0.9 90n 0.9 99.5n 0.9 100n 0.9 109.5n 0.9 110n 0.9 119.5n 0.9 120n 0.9 129.5n 0.9 130n 0 139.5n 0]
Vth54 (th54 0) vsource type=pwl wave=[0 0 9.5n 0 10n 0 19.5n 0 20n 0 29.5n 0 30n 0 39.5n 0 40n 0 49.5n 0 50n 0 59.5n 0 60n 0 69.5n 0 70n 0 79.5n 0 80n 0.9 89.5n 0.9 90n 0.9 99.5n 0.9 100n 0.9 109.5n 0.9 110n 0.9 119.5n 0.9 120n 0.9 129.5n 0.9 130n 0 139.5n 0]
Vth55 (th55 0) vsource type=pwl wave=[0 0 9.5n 0 10n 0 19.5n 0 20n 0 29.5n 0 30n 0 39.5n 0 40n 0 49.5n 0 50n 0 59.5n 0 60n 0 69.5n 0 70n 0 79.5n 0 80n 0.9 89.5n 0.9 90n 0.9 99.5n 0.9 100n 0.9 109.5n 0.9 110n 0.9 119.5n 0.9 120n 0.9 129.5n 0.9 130n 0 139.5n 0]
Vth56 (th56 0) vsource type=pwl wave=[0 0 9.5n 0 10n 0 19.5n 0 20n 0 29.5n 0 30n 0 39.5n 0 40n 0 49.5n 0 50n 0 59.5n 0 60n 0 69.5n 0 70n 0 79.5n 0 80n 0.9 89.5n 0.9 90n 0.9 99.5n 0.9 100n 0.9 109.5n 0.9 110n 0.9 119.5n 0.9 120n 0.9 129.5n 0.9 130n 0 139.5n 0]
Vth57 (th57 0) vsource type=pwl wave=[0 0 9.5n 0 10n 0 19.5n 0 20n 0 29.5n 0 30n 0 39.5n 0 40n 0 49.5n 0 50n 0 59.5n 0 60n 0 69.5n 0 70n 0 79.5n 0 80n 0.9 89.5n 0.9 90n 0.9 99.5n 0.9 100n 0.9 109.5n 0.9 110n 0.9 119.5n 0.9 120n 0.9 129.5n 0.9 130n 0 139.5n 0]
Vth58 (th58 0) vsource type=pwl wave=[0 0 9.5n 0 10n 0 19.5n 0 20n 0 29.5n 0 30n 0 39.5n 0 40n 0 49.5n 0 50n 0 59.5n 0 60n 0 69.5n 0 70n 0 79.5n 0 80n 0.9 89.5n 0.9 90n 0.9 99.5n 0.9 100n 0.9 109.5n 0.9 110n 0.9 119.5n 0.9 120n 0.9 129.5n 0.9 130n 0 139.5n 0]
Vth59 (th59 0) vsource type=pwl wave=[0 0 9.5n 0 10n 0 19.5n 0 20n 0 29.5n 0 30n 0 39.5n 0 40n 0 49.5n 0 50n 0 59.5n 0 60n 0 69.5n 0 70n 0 79.5n 0 80n 0.9 89.5n 0.9 90n 0.9 99.5n 0.9 100n 0.9 109.5n 0.9 110n 0.9 119.5n 0.9 120n 0.9 129.5n 0.9 130n 0 139.5n 0]
Vth60 (th60 0) vsource type=pwl wave=[0 0 9.5n 0 10n 0 19.5n 0 20n 0 29.5n 0 30n 0 39.5n 0 40n 0 49.5n 0 50n 0 59.5n 0 60n 0 69.5n 0 70n 0 79.5n 0 80n 0.9 89.5n 0.9 90n 0.9 99.5n 0.9 100n 0.9 109.5n 0.9 110n 0.9 119.5n 0.9 120n 0.9 129.5n 0.9 130n 0 139.5n 0]
Vth61 (th61 0) vsource type=pwl wave=[0 0 9.5n 0 10n 0 19.5n 0 20n 0 29.5n 0 30n 0 39.5n 0 40n 0 49.5n 0 50n 0 59.5n 0 60n 0 69.5n 0 70n 0 79.5n 0 80n 0.9 89.5n 0.9 90n 0.9 99.5n 0.9 100n 0.9 109.5n 0.9 110n 0.9 119.5n 0.9 120n 0.9 129.5n 0.9 130n 0 139.5n 0]
Vth62 (th62 0) vsource type=pwl wave=[0 0 9.5n 0 10n 0 19.5n 0 20n 0 29.5n 0 30n 0 39.5n 0 40n 0 49.5n 0 50n 0 59.5n 0 60n 0 69.5n 0 70n 0 79.5n 0 80n 0.9 89.5n 0.9 90n 0.9 99.5n 0.9 100n 0.9 109.5n 0.9 110n 0.9 119.5n 0.9 120n 0.9 129.5n 0.9 130n 0 139.5n 0]
Vth63 (th63 0) vsource type=pwl wave=[0 0 9.5n 0 10n 0 19.5n 0 20n 0 29.5n 0 30n 0 39.5n 0 40n 0 49.5n 0 50n 0 59.5n 0 60n 0 69.5n 0 70n 0 79.5n 0 80n 0 89.5n 0 90n 0.9 99.5n 0.9 100n 0.9 109.5n 0.9 110n 0.9 119.5n 0.9 120n 0.9 129.5n 0.9 130n 0 139.5n 0]
Vth64 (th64 0) vsource type=pwl wave=[0 0 9.5n 0 10n 0 19.5n 0 20n 0 29.5n 0 30n 0 39.5n 0 40n 0 49.5n 0 50n 0 59.5n 0 60n 0 69.5n 0 70n 0 79.5n 0 80n 0 89.5n 0 90n 0.9 99.5n 0.9 100n 0.9 109.5n 0.9 110n 0.9 119.5n 0.9 120n 0.9 129.5n 0.9 130n 0 139.5n 0]
Vth65 (th65 0) vsource type=pwl wave=[0 0 9.5n 0 10n 0 19.5n 0 20n 0 29.5n 0 30n 0 39.5n 0 40n 0 49.5n 0 50n 0 59.5n 0 60n 0 69.5n 0 70n 0 79.5n 0 80n 0 89.5n 0 90n 0.9 99.5n 0.9 100n 0.9 109.5n 0.9 110n 0.9 119.5n 0.9 120n 0.9 129.5n 0.9 130n 0 139.5n 0]
Vth66 (th66 0) vsource type=pwl wave=[0 0 9.5n 0 10n 0 19.5n 0 20n 0 29.5n 0 30n 0 39.5n 0 40n 0 49.5n 0 50n 0 59.5n 0 60n 0 69.5n 0 70n 0 79.5n 0 80n 0 89.5n 0 90n 0.9 99.5n 0.9 100n 0.9 109.5n 0.9 110n 0.9 119.5n 0.9 120n 0.9 129.5n 0.9 130n 0 139.5n 0]
Vth67 (th67 0) vsource type=pwl wave=[0 0 9.5n 0 10n 0 19.5n 0 20n 0 29.5n 0 30n 0 39.5n 0 40n 0 49.5n 0 50n 0 59.5n 0 60n 0 69.5n 0 70n 0 79.5n 0 80n 0 89.5n 0 90n 0.9 99.5n 0.9 100n 0.9 109.5n 0.9 110n 0.9 119.5n 0.9 120n 0.9 129.5n 0.9 130n 0 139.5n 0]
Vth68 (th68 0) vsource type=pwl wave=[0 0 9.5n 0 10n 0 19.5n 0 20n 0 29.5n 0 30n 0 39.5n 0 40n 0 49.5n 0 50n 0 59.5n 0 60n 0 69.5n 0 70n 0 79.5n 0 80n 0 89.5n 0 90n 0.9 99.5n 0.9 100n 0.9 109.5n 0.9 110n 0.9 119.5n 0.9 120n 0.9 129.5n 0.9 130n 0 139.5n 0]
Vth69 (th69 0) vsource type=pwl wave=[0 0 9.5n 0 10n 0 19.5n 0 20n 0 29.5n 0 30n 0 39.5n 0 40n 0 49.5n 0 50n 0 59.5n 0 60n 0 69.5n 0 70n 0 79.5n 0 80n 0 89.5n 0 90n 0.9 99.5n 0.9 100n 0.9 109.5n 0.9 110n 0.9 119.5n 0.9 120n 0.9 129.5n 0.9 130n 0 139.5n 0]
Vth70 (th70 0) vsource type=pwl wave=[0 0 9.5n 0 10n 0 19.5n 0 20n 0 29.5n 0 30n 0 39.5n 0 40n 0 49.5n 0 50n 0 59.5n 0 60n 0 69.5n 0 70n 0 79.5n 0 80n 0 89.5n 0 90n 0.9 99.5n 0.9 100n 0.9 109.5n 0.9 110n 0.9 119.5n 0.9 120n 0.9 129.5n 0.9 130n 0 139.5n 0]
Vth71 (th71 0) vsource type=pwl wave=[0 0 9.5n 0 10n 0 19.5n 0 20n 0 29.5n 0 30n 0 39.5n 0 40n 0 49.5n 0 50n 0 59.5n 0 60n 0 69.5n 0 70n 0 79.5n 0 80n 0 89.5n 0 90n 0.9 99.5n 0.9 100n 0.9 109.5n 0.9 110n 0.9 119.5n 0.9 120n 0.9 129.5n 0.9 130n 0 139.5n 0]
Vth72 (th72 0) vsource type=pwl wave=[0 0 9.5n 0 10n 0 19.5n 0 20n 0 29.5n 0 30n 0 39.5n 0 40n 0 49.5n 0 50n 0 59.5n 0 60n 0 69.5n 0 70n 0 79.5n 0 80n 0 89.5n 0 90n 0.9 99.5n 0.9 100n 0.9 109.5n 0.9 110n 0.9 119.5n 0.9 120n 0.9 129.5n 0.9 130n 0 139.5n 0]
Vth73 (th73 0) vsource type=pwl wave=[0 0 9.5n 0 10n 0 19.5n 0 20n 0 29.5n 0 30n 0 39.5n 0 40n 0 49.5n 0 50n 0 59.5n 0 60n 0 69.5n 0 70n 0 79.5n 0 80n 0 89.5n 0 90n 0.9 99.5n 0.9 100n 0.9 109.5n 0.9 110n 0.9 119.5n 0.9 120n 0.9 129.5n 0.9 130n 0 139.5n 0]
Vth74 (th74 0) vsource type=pwl wave=[0 0 9.5n 0 10n 0 19.5n 0 20n 0 29.5n 0 30n 0 39.5n 0 40n 0 49.5n 0 50n 0 59.5n 0 60n 0 69.5n 0 70n 0 79.5n 0 80n 0 89.5n 0 90n 0.9 99.5n 0.9 100n 0.9 109.5n 0.9 110n 0.9 119.5n 0.9 120n 0.9 129.5n 0.9 130n 0 139.5n 0]
Vth75 (th75 0) vsource type=pwl wave=[0 0 9.5n 0 10n 0 19.5n 0 20n 0 29.5n 0 30n 0 39.5n 0 40n 0 49.5n 0 50n 0 59.5n 0 60n 0 69.5n 0 70n 0 79.5n 0 80n 0 89.5n 0 90n 0.9 99.5n 0.9 100n 0.9 109.5n 0.9 110n 0.9 119.5n 0.9 120n 0.9 129.5n 0.9 130n 0 139.5n 0]
Vth76 (th76 0) vsource type=pwl wave=[0 0 9.5n 0 10n 0 19.5n 0 20n 0 29.5n 0 30n 0 39.5n 0 40n 0 49.5n 0 50n 0 59.5n 0 60n 0 69.5n 0 70n 0 79.5n 0 80n 0 89.5n 0 90n 0.9 99.5n 0.9 100n 0.9 109.5n 0.9 110n 0.9 119.5n 0.9 120n 0.9 129.5n 0.9 130n 0 139.5n 0]
Vth77 (th77 0) vsource type=pwl wave=[0 0 9.5n 0 10n 0 19.5n 0 20n 0 29.5n 0 30n 0 39.5n 0 40n 0 49.5n 0 50n 0 59.5n 0 60n 0 69.5n 0 70n 0 79.5n 0 80n 0 89.5n 0 90n 0.9 99.5n 0.9 100n 0.9 109.5n 0.9 110n 0.9 119.5n 0.9 120n 0.9 129.5n 0.9 130n 0 139.5n 0]
Vth78 (th78 0) vsource type=pwl wave=[0 0 9.5n 0 10n 0 19.5n 0 20n 0 29.5n 0 30n 0 39.5n 0 40n 0 49.5n 0 50n 0 59.5n 0 60n 0 69.5n 0 70n 0 79.5n 0 80n 0 89.5n 0 90n 0.9 99.5n 0.9 100n 0.9 109.5n 0.9 110n 0.9 119.5n 0.9 120n 0.9 129.5n 0.9 130n 0 139.5n 0]
Vth79 (th79 0) vsource type=pwl wave=[0 0 9.5n 0 10n 0 19.5n 0 20n 0 29.5n 0 30n 0 39.5n 0 40n 0 49.5n 0 50n 0 59.5n 0 60n 0 69.5n 0 70n 0 79.5n 0 80n 0 89.5n 0 90n 0.9 99.5n 0.9 100n 0.9 109.5n 0.9 110n 0.9 119.5n 0.9 120n 0.9 129.5n 0.9 130n 0 139.5n 0]
Vth80 (th80 0) vsource type=pwl wave=[0 0 9.5n 0 10n 0 19.5n 0 20n 0 29.5n 0 30n 0 39.5n 0 40n 0 49.5n 0 50n 0 59.5n 0 60n 0 69.5n 0 70n 0 79.5n 0 80n 0 89.5n 0 90n 0.9 99.5n 0.9 100n 0.9 109.5n 0.9 110n 0.9 119.5n 0.9 120n 0.9 129.5n 0.9 130n 0 139.5n 0]
Vth81 (th81 0) vsource type=pwl wave=[0 0 9.5n 0 10n 0 19.5n 0 20n 0 29.5n 0 30n 0 39.5n 0 40n 0 49.5n 0 50n 0 59.5n 0 60n 0 69.5n 0 70n 0 79.5n 0 80n 0 89.5n 0 90n 0.9 99.5n 0.9 100n 0.9 109.5n 0.9 110n 0.9 119.5n 0.9 120n 0.9 129.5n 0.9 130n 0 139.5n 0]
Vth82 (th82 0) vsource type=pwl wave=[0 0 9.5n 0 10n 0 19.5n 0 20n 0 29.5n 0 30n 0 39.5n 0 40n 0 49.5n 0 50n 0 59.5n 0 60n 0 69.5n 0 70n 0 79.5n 0 80n 0 89.5n 0 90n 0.9 99.5n 0.9 100n 0.9 109.5n 0.9 110n 0.9 119.5n 0.9 120n 0.9 129.5n 0.9 130n 0 139.5n 0]
Vth83 (th83 0) vsource type=pwl wave=[0 0 9.5n 0 10n 0 19.5n 0 20n 0 29.5n 0 30n 0 39.5n 0 40n 0 49.5n 0 50n 0 59.5n 0 60n 0 69.5n 0 70n 0 79.5n 0 80n 0 89.5n 0 90n 0.9 99.5n 0.9 100n 0.9 109.5n 0.9 110n 0.9 119.5n 0.9 120n 0.9 129.5n 0.9 130n 0 139.5n 0]
Vth84 (th84 0) vsource type=pwl wave=[0 0 9.5n 0 10n 0 19.5n 0 20n 0 29.5n 0 30n 0 39.5n 0 40n 0 49.5n 0 50n 0 59.5n 0 60n 0 69.5n 0 70n 0 79.5n 0 80n 0 89.5n 0 90n 0.9 99.5n 0.9 100n 0.9 109.5n 0.9 110n 0.9 119.5n 0.9 120n 0.9 129.5n 0.9 130n 0 139.5n 0]
Vth85 (th85 0) vsource type=pwl wave=[0 0 9.5n 0 10n 0 19.5n 0 20n 0 29.5n 0 30n 0 39.5n 0 40n 0 49.5n 0 50n 0 59.5n 0 60n 0 69.5n 0 70n 0 79.5n 0 80n 0 89.5n 0 90n 0.9 99.5n 0.9 100n 0.9 109.5n 0.9 110n 0.9 119.5n 0.9 120n 0.9 129.5n 0.9 130n 0 139.5n 0]
Vth86 (th86 0) vsource type=pwl wave=[0 0 9.5n 0 10n 0 19.5n 0 20n 0 29.5n 0 30n 0 39.5n 0 40n 0 49.5n 0 50n 0 59.5n 0 60n 0 69.5n 0 70n 0 79.5n 0 80n 0 89.5n 0 90n 0.9 99.5n 0.9 100n 0.9 109.5n 0.9 110n 0.9 119.5n 0.9 120n 0.9 129.5n 0.9 130n 0 139.5n 0]
Vth87 (th87 0) vsource type=pwl wave=[0 0 9.5n 0 10n 0 19.5n 0 20n 0 29.5n 0 30n 0 39.5n 0 40n 0 49.5n 0 50n 0 59.5n 0 60n 0 69.5n 0 70n 0 79.5n 0 80n 0 89.5n 0 90n 0.9 99.5n 0.9 100n 0.9 109.5n 0.9 110n 0.9 119.5n 0.9 120n 0.9 129.5n 0.9 130n 0 139.5n 0]
Vth88 (th88 0) vsource type=pwl wave=[0 0 9.5n 0 10n 0 19.5n 0 20n 0 29.5n 0 30n 0 39.5n 0 40n 0 49.5n 0 50n 0 59.5n 0 60n 0 69.5n 0 70n 0 79.5n 0 80n 0 89.5n 0 90n 0.9 99.5n 0.9 100n 0.9 109.5n 0.9 110n 0.9 119.5n 0.9 120n 0.9 129.5n 0.9 130n 0 139.5n 0]
Vth89 (th89 0) vsource type=pwl wave=[0 0 9.5n 0 10n 0 19.5n 0 20n 0 29.5n 0 30n 0 39.5n 0 40n 0 49.5n 0 50n 0 59.5n 0 60n 0 69.5n 0 70n 0 79.5n 0 80n 0 89.5n 0 90n 0.9 99.5n 0.9 100n 0.9 109.5n 0.9 110n 0.9 119.5n 0.9 120n 0.9 129.5n 0.9 130n 0 139.5n 0]
Vth90 (th90 0) vsource type=pwl wave=[0 0 9.5n 0 10n 0 19.5n 0 20n 0 29.5n 0 30n 0 39.5n 0 40n 0 49.5n 0 50n 0 59.5n 0 60n 0 69.5n 0 70n 0 79.5n 0 80n 0 89.5n 0 90n 0.9 99.5n 0.9 100n 0.9 109.5n 0.9 110n 0.9 119.5n 0.9 120n 0.9 129.5n 0.9 130n 0 139.5n 0]
Vth91 (th91 0) vsource type=pwl wave=[0 0 9.5n 0 10n 0 19.5n 0 20n 0 29.5n 0 30n 0 39.5n 0 40n 0 49.5n 0 50n 0 59.5n 0 60n 0 69.5n 0 70n 0 79.5n 0 80n 0 89.5n 0 90n 0.9 99.5n 0.9 100n 0.9 109.5n 0.9 110n 0.9 119.5n 0.9 120n 0.9 129.5n 0.9 130n 0 139.5n 0]
Vth92 (th92 0) vsource type=pwl wave=[0 0 9.5n 0 10n 0 19.5n 0 20n 0 29.5n 0 30n 0 39.5n 0 40n 0 49.5n 0 50n 0 59.5n 0 60n 0 69.5n 0 70n 0 79.5n 0 80n 0 89.5n 0 90n 0.9 99.5n 0.9 100n 0.9 109.5n 0.9 110n 0.9 119.5n 0.9 120n 0.9 129.5n 0.9 130n 0 139.5n 0]
Vth93 (th93 0) vsource type=pwl wave=[0 0 9.5n 0 10n 0 19.5n 0 20n 0 29.5n 0 30n 0 39.5n 0 40n 0 49.5n 0 50n 0 59.5n 0 60n 0 69.5n 0 70n 0 79.5n 0 80n 0 89.5n 0 90n 0.9 99.5n 0.9 100n 0.9 109.5n 0.9 110n 0.9 119.5n 0.9 120n 0.9 129.5n 0.9 130n 0 139.5n 0]
Vth94 (th94 0) vsource type=pwl wave=[0 0 9.5n 0 10n 0 19.5n 0 20n 0 29.5n 0 30n 0 39.5n 0 40n 0 49.5n 0 50n 0 59.5n 0 60n 0 69.5n 0 70n 0 79.5n 0 80n 0 89.5n 0 90n 0.9 99.5n 0.9 100n 0.9 109.5n 0.9 110n 0.9 119.5n 0.9 120n 0.9 129.5n 0.9 130n 0 139.5n 0]
Vth95 (th95 0) vsource type=pwl wave=[0 0 9.5n 0 10n 0 19.5n 0 20n 0 29.5n 0 30n 0 39.5n 0 40n 0 49.5n 0 50n 0 59.5n 0 60n 0 69.5n 0 70n 0 79.5n 0 80n 0 89.5n 0 90n 0.9 99.5n 0.9 100n 0.9 109.5n 0.9 110n 0.9 119.5n 0.9 120n 0.9 129.5n 0.9 130n 0 139.5n 0]
Vth96 (th96 0) vsource type=pwl wave=[0 0 9.5n 0 10n 0 19.5n 0 20n 0 29.5n 0 30n 0 39.5n 0 40n 0 49.5n 0 50n 0 59.5n 0 60n 0 69.5n 0 70n 0 79.5n 0 80n 0 89.5n 0 90n 0.9 99.5n 0.9 100n 0.9 109.5n 0.9 110n 0.9 119.5n 0.9 120n 0.9 129.5n 0.9 130n 0 139.5n 0]
Vth97 (th97 0) vsource type=pwl wave=[0 0 9.5n 0 10n 0 19.5n 0 20n 0 29.5n 0 30n 0 39.5n 0 40n 0 49.5n 0 50n 0 59.5n 0 60n 0 69.5n 0 70n 0 79.5n 0 80n 0 89.5n 0 90n 0.9 99.5n 0.9 100n 0.9 109.5n 0.9 110n 0.9 119.5n 0.9 120n 0.9 129.5n 0.9 130n 0 139.5n 0]
Vth98 (th98 0) vsource type=pwl wave=[0 0 9.5n 0 10n 0 19.5n 0 20n 0 29.5n 0 30n 0 39.5n 0 40n 0 49.5n 0 50n 0 59.5n 0 60n 0 69.5n 0 70n 0 79.5n 0 80n 0 89.5n 0 90n 0.9 99.5n 0.9 100n 0.9 109.5n 0.9 110n 0.9 119.5n 0.9 120n 0.9 129.5n 0.9 130n 0 139.5n 0]
Vth99 (th99 0) vsource type=pwl wave=[0 0 9.5n 0 10n 0 19.5n 0 20n 0 29.5n 0 30n 0 39.5n 0 40n 0 49.5n 0 50n 0 59.5n 0 60n 0 69.5n 0 70n 0 79.5n 0 80n 0 89.5n 0 90n 0.9 99.5n 0.9 100n 0.9 109.5n 0.9 110n 0.9 119.5n 0.9 120n 0.9 129.5n 0.9 130n 0 139.5n 0]
Vth100 (th100 0) vsource type=pwl wave=[0 0 9.5n 0 10n 0 19.5n 0 20n 0 29.5n 0 30n 0 39.5n 0 40n 0 49.5n 0 50n 0 59.5n 0 60n 0 69.5n 0 70n 0 79.5n 0 80n 0 89.5n 0 90n 0.9 99.5n 0.9 100n 0.9 109.5n 0.9 110n 0.9 119.5n 0.9 120n 0.9 129.5n 0.9 130n 0 139.5n 0]
Vth101 (th101 0) vsource type=pwl wave=[0 0 9.5n 0 10n 0 19.5n 0 20n 0 29.5n 0 30n 0 39.5n 0 40n 0 49.5n 0 50n 0 59.5n 0 60n 0 69.5n 0 70n 0 79.5n 0 80n 0 89.5n 0 90n 0.9 99.5n 0.9 100n 0.9 109.5n 0.9 110n 0.9 119.5n 0.9 120n 0.9 129.5n 0.9 130n 0 139.5n 0]
Vth102 (th102 0) vsource type=pwl wave=[0 0 9.5n 0 10n 0 19.5n 0 20n 0 29.5n 0 30n 0 39.5n 0 40n 0 49.5n 0 50n 0 59.5n 0 60n 0 69.5n 0 70n 0 79.5n 0 80n 0 89.5n 0 90n 0.9 99.5n 0.9 100n 0.9 109.5n 0.9 110n 0.9 119.5n 0.9 120n 0.9 129.5n 0.9 130n 0 139.5n 0]
Vth103 (th103 0) vsource type=pwl wave=[0 0 9.5n 0 10n 0 19.5n 0 20n 0 29.5n 0 30n 0 39.5n 0 40n 0 49.5n 0 50n 0 59.5n 0 60n 0 69.5n 0 70n 0 79.5n 0 80n 0 89.5n 0 90n 0.9 99.5n 0.9 100n 0.9 109.5n 0.9 110n 0.9 119.5n 0.9 120n 0.9 129.5n 0.9 130n 0 139.5n 0]
Vth104 (th104 0) vsource type=pwl wave=[0 0 9.5n 0 10n 0 19.5n 0 20n 0 29.5n 0 30n 0 39.5n 0 40n 0 49.5n 0 50n 0 59.5n 0 60n 0 69.5n 0 70n 0 79.5n 0 80n 0 89.5n 0 90n 0.9 99.5n 0.9 100n 0.9 109.5n 0.9 110n 0.9 119.5n 0.9 120n 0.9 129.5n 0.9 130n 0 139.5n 0]
Vth105 (th105 0) vsource type=pwl wave=[0 0 9.5n 0 10n 0 19.5n 0 20n 0 29.5n 0 30n 0 39.5n 0 40n 0 49.5n 0 50n 0 59.5n 0 60n 0 69.5n 0 70n 0 79.5n 0 80n 0 89.5n 0 90n 0.9 99.5n 0.9 100n 0.9 109.5n 0.9 110n 0.9 119.5n 0.9 120n 0.9 129.5n 0.9 130n 0 139.5n 0]
Vth106 (th106 0) vsource type=pwl wave=[0 0 9.5n 0 10n 0 19.5n 0 20n 0 29.5n 0 30n 0 39.5n 0 40n 0 49.5n 0 50n 0 59.5n 0 60n 0 69.5n 0 70n 0 79.5n 0 80n 0 89.5n 0 90n 0.9 99.5n 0.9 100n 0.9 109.5n 0.9 110n 0.9 119.5n 0.9 120n 0.9 129.5n 0.9 130n 0 139.5n 0]
Vth107 (th107 0) vsource type=pwl wave=[0 0 9.5n 0 10n 0 19.5n 0 20n 0 29.5n 0 30n 0 39.5n 0 40n 0 49.5n 0 50n 0 59.5n 0 60n 0 69.5n 0 70n 0 79.5n 0 80n 0 89.5n 0 90n 0.9 99.5n 0.9 100n 0.9 109.5n 0.9 110n 0.9 119.5n 0.9 120n 0.9 129.5n 0.9 130n 0 139.5n 0]
Vth108 (th108 0) vsource type=pwl wave=[0 0 9.5n 0 10n 0 19.5n 0 20n 0 29.5n 0 30n 0 39.5n 0 40n 0 49.5n 0 50n 0 59.5n 0 60n 0 69.5n 0 70n 0 79.5n 0 80n 0 89.5n 0 90n 0.9 99.5n 0.9 100n 0.9 109.5n 0.9 110n 0.9 119.5n 0.9 120n 0.9 129.5n 0.9 130n 0 139.5n 0]
Vth109 (th109 0) vsource type=pwl wave=[0 0 9.5n 0 10n 0 19.5n 0 20n 0 29.5n 0 30n 0 39.5n 0 40n 0 49.5n 0 50n 0 59.5n 0 60n 0 69.5n 0 70n 0 79.5n 0 80n 0 89.5n 0 90n 0.9 99.5n 0.9 100n 0.9 109.5n 0.9 110n 0.9 119.5n 0.9 120n 0.9 129.5n 0.9 130n 0 139.5n 0]
Vth110 (th110 0) vsource type=pwl wave=[0 0 9.5n 0 10n 0 19.5n 0 20n 0 29.5n 0 30n 0 39.5n 0 40n 0 49.5n 0 50n 0 59.5n 0 60n 0 69.5n 0 70n 0 79.5n 0 80n 0 89.5n 0 90n 0.9 99.5n 0.9 100n 0.9 109.5n 0.9 110n 0.9 119.5n 0.9 120n 0.9 129.5n 0.9 130n 0 139.5n 0]
Vth111 (th111 0) vsource type=pwl wave=[0 0 9.5n 0 10n 0 19.5n 0 20n 0 29.5n 0 30n 0 39.5n 0 40n 0 49.5n 0 50n 0 59.5n 0 60n 0 69.5n 0 70n 0 79.5n 0 80n 0 89.5n 0 90n 0.9 99.5n 0.9 100n 0.9 109.5n 0.9 110n 0.9 119.5n 0.9 120n 0.9 129.5n 0.9 130n 0 139.5n 0]
Vth112 (th112 0) vsource type=pwl wave=[0 0 9.5n 0 10n 0 19.5n 0 20n 0 29.5n 0 30n 0 39.5n 0 40n 0 49.5n 0 50n 0 59.5n 0 60n 0 69.5n 0 70n 0 79.5n 0 80n 0 89.5n 0 90n 0.9 99.5n 0.9 100n 0.9 109.5n 0.9 110n 0.9 119.5n 0.9 120n 0.9 129.5n 0.9 130n 0 139.5n 0]
Vth113 (th113 0) vsource type=pwl wave=[0 0 9.5n 0 10n 0 19.5n 0 20n 0 29.5n 0 30n 0 39.5n 0 40n 0 49.5n 0 50n 0 59.5n 0 60n 0 69.5n 0 70n 0 79.5n 0 80n 0 89.5n 0 90n 0.9 99.5n 0.9 100n 0.9 109.5n 0.9 110n 0.9 119.5n 0.9 120n 0.9 129.5n 0.9 130n 0 139.5n 0]
Vth114 (th114 0) vsource type=pwl wave=[0 0 9.5n 0 10n 0 19.5n 0 20n 0 29.5n 0 30n 0 39.5n 0 40n 0 49.5n 0 50n 0 59.5n 0 60n 0 69.5n 0 70n 0 79.5n 0 80n 0 89.5n 0 90n 0.9 99.5n 0.9 100n 0.9 109.5n 0.9 110n 0.9 119.5n 0.9 120n 0.9 129.5n 0.9 130n 0 139.5n 0]
Vth115 (th115 0) vsource type=pwl wave=[0 0 9.5n 0 10n 0 19.5n 0 20n 0 29.5n 0 30n 0 39.5n 0 40n 0 49.5n 0 50n 0 59.5n 0 60n 0 69.5n 0 70n 0 79.5n 0 80n 0 89.5n 0 90n 0.9 99.5n 0.9 100n 0.9 109.5n 0.9 110n 0.9 119.5n 0.9 120n 0.9 129.5n 0.9 130n 0 139.5n 0]
Vth116 (th116 0) vsource type=pwl wave=[0 0 9.5n 0 10n 0 19.5n 0 20n 0 29.5n 0 30n 0 39.5n 0 40n 0 49.5n 0 50n 0 59.5n 0 60n 0 69.5n 0 70n 0 79.5n 0 80n 0 89.5n 0 90n 0.9 99.5n 0.9 100n 0.9 109.5n 0.9 110n 0.9 119.5n 0.9 120n 0.9 129.5n 0.9 130n 0 139.5n 0]
Vth117 (th117 0) vsource type=pwl wave=[0 0 9.5n 0 10n 0 19.5n 0 20n 0 29.5n 0 30n 0 39.5n 0 40n 0 49.5n 0 50n 0 59.5n 0 60n 0 69.5n 0 70n 0 79.5n 0 80n 0 89.5n 0 90n 0.9 99.5n 0.9 100n 0.9 109.5n 0.9 110n 0.9 119.5n 0.9 120n 0.9 129.5n 0.9 130n 0 139.5n 0]
Vth118 (th118 0) vsource type=pwl wave=[0 0 9.5n 0 10n 0 19.5n 0 20n 0 29.5n 0 30n 0 39.5n 0 40n 0 49.5n 0 50n 0 59.5n 0 60n 0 69.5n 0 70n 0 79.5n 0 80n 0 89.5n 0 90n 0.9 99.5n 0.9 100n 0.9 109.5n 0.9 110n 0.9 119.5n 0.9 120n 0.9 129.5n 0.9 130n 0 139.5n 0]
Vth119 (th119 0) vsource type=pwl wave=[0 0 9.5n 0 10n 0 19.5n 0 20n 0 29.5n 0 30n 0 39.5n 0 40n 0 49.5n 0 50n 0 59.5n 0 60n 0 69.5n 0 70n 0 79.5n 0 80n 0 89.5n 0 90n 0.9 99.5n 0.9 100n 0.9 109.5n 0.9 110n 0.9 119.5n 0.9 120n 0.9 129.5n 0.9 130n 0 139.5n 0]
Vth120 (th120 0) vsource type=pwl wave=[0 0 9.5n 0 10n 0 19.5n 0 20n 0 29.5n 0 30n 0 39.5n 0 40n 0 49.5n 0 50n 0 59.5n 0 60n 0 69.5n 0 70n 0 79.5n 0 80n 0 89.5n 0 90n 0.9 99.5n 0.9 100n 0.9 109.5n 0.9 110n 0.9 119.5n 0.9 120n 0.9 129.5n 0.9 130n 0 139.5n 0]
Vth121 (th121 0) vsource type=pwl wave=[0 0 9.5n 0 10n 0 19.5n 0 20n 0 29.5n 0 30n 0 39.5n 0 40n 0 49.5n 0 50n 0 59.5n 0 60n 0 69.5n 0 70n 0 79.5n 0 80n 0 89.5n 0 90n 0.9 99.5n 0.9 100n 0.9 109.5n 0.9 110n 0.9 119.5n 0.9 120n 0.9 129.5n 0.9 130n 0 139.5n 0]
Vth122 (th122 0) vsource type=pwl wave=[0 0 9.5n 0 10n 0 19.5n 0 20n 0 29.5n 0 30n 0 39.5n 0 40n 0 49.5n 0 50n 0 59.5n 0 60n 0 69.5n 0 70n 0 79.5n 0 80n 0 89.5n 0 90n 0.9 99.5n 0.9 100n 0.9 109.5n 0.9 110n 0.9 119.5n 0.9 120n 0.9 129.5n 0.9 130n 0 139.5n 0]
Vth123 (th123 0) vsource type=pwl wave=[0 0 9.5n 0 10n 0 19.5n 0 20n 0 29.5n 0 30n 0 39.5n 0 40n 0 49.5n 0 50n 0 59.5n 0 60n 0 69.5n 0 70n 0 79.5n 0 80n 0 89.5n 0 90n 0.9 99.5n 0.9 100n 0.9 109.5n 0.9 110n 0.9 119.5n 0.9 120n 0.9 129.5n 0.9 130n 0 139.5n 0]
Vth124 (th124 0) vsource type=pwl wave=[0 0 9.5n 0 10n 0 19.5n 0 20n 0 29.5n 0 30n 0 39.5n 0 40n 0 49.5n 0 50n 0 59.5n 0 60n 0 69.5n 0 70n 0 79.5n 0 80n 0 89.5n 0 90n 0.9 99.5n 0.9 100n 0.9 109.5n 0.9 110n 0.9 119.5n 0.9 120n 0.9 129.5n 0.9 130n 0 139.5n 0]
Vth125 (th125 0) vsource type=pwl wave=[0 0 9.5n 0 10n 0 19.5n 0 20n 0 29.5n 0 30n 0 39.5n 0 40n 0 49.5n 0 50n 0 59.5n 0 60n 0 69.5n 0 70n 0 79.5n 0 80n 0 89.5n 0 90n 0.9 99.5n 0.9 100n 0.9 109.5n 0.9 110n 0.9 119.5n 0.9 120n 0.9 129.5n 0.9 130n 0 139.5n 0]
Vth126 (th126 0) vsource type=pwl wave=[0 0 9.5n 0 10n 0 19.5n 0 20n 0 29.5n 0 30n 0 39.5n 0 40n 0 49.5n 0 50n 0 59.5n 0 60n 0 69.5n 0 70n 0 79.5n 0 80n 0 89.5n 0 90n 0.9 99.5n 0.9 100n 0.9 109.5n 0.9 110n 0.9 119.5n 0.9 120n 0.9 129.5n 0.9 130n 0 139.5n 0]
Vth127 (th127 0) vsource type=pwl wave=[0 0 9.5n 0 10n 0 19.5n 0 20n 0 29.5n 0 30n 0 39.5n 0 40n 0 49.5n 0 50n 0 59.5n 0 60n 0 69.5n 0 70n 0 79.5n 0 80n 0 89.5n 0 90n 0 99.5n 0 100n 0.9 109.5n 0.9 110n 0.9 119.5n 0.9 120n 0.9 129.5n 0.9 130n 0 139.5n 0]
Vth128 (th128 0) vsource type=pwl wave=[0 0 9.5n 0 10n 0 19.5n 0 20n 0 29.5n 0 30n 0 39.5n 0 40n 0 49.5n 0 50n 0 59.5n 0 60n 0 69.5n 0 70n 0 79.5n 0 80n 0 89.5n 0 90n 0 99.5n 0 100n 0 109.5n 0 110n 0.9 119.5n 0.9 120n 0.9 129.5n 0.9 130n 0 139.5n 0]
Vth129 (th129 0) vsource type=pwl wave=[0 0 9.5n 0 10n 0 19.5n 0 20n 0 29.5n 0 30n 0 39.5n 0 40n 0 49.5n 0 50n 0 59.5n 0 60n 0 69.5n 0 70n 0 79.5n 0 80n 0 89.5n 0 90n 0 99.5n 0 100n 0 109.5n 0 110n 0.9 119.5n 0.9 120n 0.9 129.5n 0.9 130n 0 139.5n 0]
Vth130 (th130 0) vsource type=pwl wave=[0 0 9.5n 0 10n 0 19.5n 0 20n 0 29.5n 0 30n 0 39.5n 0 40n 0 49.5n 0 50n 0 59.5n 0 60n 0 69.5n 0 70n 0 79.5n 0 80n 0 89.5n 0 90n 0 99.5n 0 100n 0 109.5n 0 110n 0.9 119.5n 0.9 120n 0.9 129.5n 0.9 130n 0 139.5n 0]
Vth131 (th131 0) vsource type=pwl wave=[0 0 9.5n 0 10n 0 19.5n 0 20n 0 29.5n 0 30n 0 39.5n 0 40n 0 49.5n 0 50n 0 59.5n 0 60n 0 69.5n 0 70n 0 79.5n 0 80n 0 89.5n 0 90n 0 99.5n 0 100n 0 109.5n 0 110n 0.9 119.5n 0.9 120n 0.9 129.5n 0.9 130n 0 139.5n 0]
Vth132 (th132 0) vsource type=pwl wave=[0 0 9.5n 0 10n 0 19.5n 0 20n 0 29.5n 0 30n 0 39.5n 0 40n 0 49.5n 0 50n 0 59.5n 0 60n 0 69.5n 0 70n 0 79.5n 0 80n 0 89.5n 0 90n 0 99.5n 0 100n 0 109.5n 0 110n 0.9 119.5n 0.9 120n 0.9 129.5n 0.9 130n 0 139.5n 0]
Vth133 (th133 0) vsource type=pwl wave=[0 0 9.5n 0 10n 0 19.5n 0 20n 0 29.5n 0 30n 0 39.5n 0 40n 0 49.5n 0 50n 0 59.5n 0 60n 0 69.5n 0 70n 0 79.5n 0 80n 0 89.5n 0 90n 0 99.5n 0 100n 0 109.5n 0 110n 0.9 119.5n 0.9 120n 0.9 129.5n 0.9 130n 0 139.5n 0]
Vth134 (th134 0) vsource type=pwl wave=[0 0 9.5n 0 10n 0 19.5n 0 20n 0 29.5n 0 30n 0 39.5n 0 40n 0 49.5n 0 50n 0 59.5n 0 60n 0 69.5n 0 70n 0 79.5n 0 80n 0 89.5n 0 90n 0 99.5n 0 100n 0 109.5n 0 110n 0.9 119.5n 0.9 120n 0.9 129.5n 0.9 130n 0 139.5n 0]
Vth135 (th135 0) vsource type=pwl wave=[0 0 9.5n 0 10n 0 19.5n 0 20n 0 29.5n 0 30n 0 39.5n 0 40n 0 49.5n 0 50n 0 59.5n 0 60n 0 69.5n 0 70n 0 79.5n 0 80n 0 89.5n 0 90n 0 99.5n 0 100n 0 109.5n 0 110n 0.9 119.5n 0.9 120n 0.9 129.5n 0.9 130n 0 139.5n 0]
Vth136 (th136 0) vsource type=pwl wave=[0 0 9.5n 0 10n 0 19.5n 0 20n 0 29.5n 0 30n 0 39.5n 0 40n 0 49.5n 0 50n 0 59.5n 0 60n 0 69.5n 0 70n 0 79.5n 0 80n 0 89.5n 0 90n 0 99.5n 0 100n 0 109.5n 0 110n 0.9 119.5n 0.9 120n 0.9 129.5n 0.9 130n 0 139.5n 0]
Vth137 (th137 0) vsource type=pwl wave=[0 0 9.5n 0 10n 0 19.5n 0 20n 0 29.5n 0 30n 0 39.5n 0 40n 0 49.5n 0 50n 0 59.5n 0 60n 0 69.5n 0 70n 0 79.5n 0 80n 0 89.5n 0 90n 0 99.5n 0 100n 0 109.5n 0 110n 0.9 119.5n 0.9 120n 0.9 129.5n 0.9 130n 0 139.5n 0]
Vth138 (th138 0) vsource type=pwl wave=[0 0 9.5n 0 10n 0 19.5n 0 20n 0 29.5n 0 30n 0 39.5n 0 40n 0 49.5n 0 50n 0 59.5n 0 60n 0 69.5n 0 70n 0 79.5n 0 80n 0 89.5n 0 90n 0 99.5n 0 100n 0 109.5n 0 110n 0.9 119.5n 0.9 120n 0.9 129.5n 0.9 130n 0 139.5n 0]
Vth139 (th139 0) vsource type=pwl wave=[0 0 9.5n 0 10n 0 19.5n 0 20n 0 29.5n 0 30n 0 39.5n 0 40n 0 49.5n 0 50n 0 59.5n 0 60n 0 69.5n 0 70n 0 79.5n 0 80n 0 89.5n 0 90n 0 99.5n 0 100n 0 109.5n 0 110n 0.9 119.5n 0.9 120n 0.9 129.5n 0.9 130n 0 139.5n 0]
Vth140 (th140 0) vsource type=pwl wave=[0 0 9.5n 0 10n 0 19.5n 0 20n 0 29.5n 0 30n 0 39.5n 0 40n 0 49.5n 0 50n 0 59.5n 0 60n 0 69.5n 0 70n 0 79.5n 0 80n 0 89.5n 0 90n 0 99.5n 0 100n 0 109.5n 0 110n 0.9 119.5n 0.9 120n 0.9 129.5n 0.9 130n 0 139.5n 0]
Vth141 (th141 0) vsource type=pwl wave=[0 0 9.5n 0 10n 0 19.5n 0 20n 0 29.5n 0 30n 0 39.5n 0 40n 0 49.5n 0 50n 0 59.5n 0 60n 0 69.5n 0 70n 0 79.5n 0 80n 0 89.5n 0 90n 0 99.5n 0 100n 0 109.5n 0 110n 0.9 119.5n 0.9 120n 0.9 129.5n 0.9 130n 0 139.5n 0]
Vth142 (th142 0) vsource type=pwl wave=[0 0 9.5n 0 10n 0 19.5n 0 20n 0 29.5n 0 30n 0 39.5n 0 40n 0 49.5n 0 50n 0 59.5n 0 60n 0 69.5n 0 70n 0 79.5n 0 80n 0 89.5n 0 90n 0 99.5n 0 100n 0 109.5n 0 110n 0.9 119.5n 0.9 120n 0.9 129.5n 0.9 130n 0 139.5n 0]
Vth143 (th143 0) vsource type=pwl wave=[0 0 9.5n 0 10n 0 19.5n 0 20n 0 29.5n 0 30n 0 39.5n 0 40n 0 49.5n 0 50n 0 59.5n 0 60n 0 69.5n 0 70n 0 79.5n 0 80n 0 89.5n 0 90n 0 99.5n 0 100n 0 109.5n 0 110n 0.9 119.5n 0.9 120n 0.9 129.5n 0.9 130n 0 139.5n 0]
Vth144 (th144 0) vsource type=pwl wave=[0 0 9.5n 0 10n 0 19.5n 0 20n 0 29.5n 0 30n 0 39.5n 0 40n 0 49.5n 0 50n 0 59.5n 0 60n 0 69.5n 0 70n 0 79.5n 0 80n 0 89.5n 0 90n 0 99.5n 0 100n 0 109.5n 0 110n 0.9 119.5n 0.9 120n 0.9 129.5n 0.9 130n 0 139.5n 0]
Vth145 (th145 0) vsource type=pwl wave=[0 0 9.5n 0 10n 0 19.5n 0 20n 0 29.5n 0 30n 0 39.5n 0 40n 0 49.5n 0 50n 0 59.5n 0 60n 0 69.5n 0 70n 0 79.5n 0 80n 0 89.5n 0 90n 0 99.5n 0 100n 0 109.5n 0 110n 0.9 119.5n 0.9 120n 0.9 129.5n 0.9 130n 0 139.5n 0]
Vth146 (th146 0) vsource type=pwl wave=[0 0 9.5n 0 10n 0 19.5n 0 20n 0 29.5n 0 30n 0 39.5n 0 40n 0 49.5n 0 50n 0 59.5n 0 60n 0 69.5n 0 70n 0 79.5n 0 80n 0 89.5n 0 90n 0 99.5n 0 100n 0 109.5n 0 110n 0.9 119.5n 0.9 120n 0.9 129.5n 0.9 130n 0 139.5n 0]
Vth147 (th147 0) vsource type=pwl wave=[0 0 9.5n 0 10n 0 19.5n 0 20n 0 29.5n 0 30n 0 39.5n 0 40n 0 49.5n 0 50n 0 59.5n 0 60n 0 69.5n 0 70n 0 79.5n 0 80n 0 89.5n 0 90n 0 99.5n 0 100n 0 109.5n 0 110n 0.9 119.5n 0.9 120n 0.9 129.5n 0.9 130n 0 139.5n 0]
Vth148 (th148 0) vsource type=pwl wave=[0 0 9.5n 0 10n 0 19.5n 0 20n 0 29.5n 0 30n 0 39.5n 0 40n 0 49.5n 0 50n 0 59.5n 0 60n 0 69.5n 0 70n 0 79.5n 0 80n 0 89.5n 0 90n 0 99.5n 0 100n 0 109.5n 0 110n 0.9 119.5n 0.9 120n 0.9 129.5n 0.9 130n 0 139.5n 0]
Vth149 (th149 0) vsource type=pwl wave=[0 0 9.5n 0 10n 0 19.5n 0 20n 0 29.5n 0 30n 0 39.5n 0 40n 0 49.5n 0 50n 0 59.5n 0 60n 0 69.5n 0 70n 0 79.5n 0 80n 0 89.5n 0 90n 0 99.5n 0 100n 0 109.5n 0 110n 0.9 119.5n 0.9 120n 0.9 129.5n 0.9 130n 0 139.5n 0]
Vth150 (th150 0) vsource type=pwl wave=[0 0 9.5n 0 10n 0 19.5n 0 20n 0 29.5n 0 30n 0 39.5n 0 40n 0 49.5n 0 50n 0 59.5n 0 60n 0 69.5n 0 70n 0 79.5n 0 80n 0 89.5n 0 90n 0 99.5n 0 100n 0 109.5n 0 110n 0.9 119.5n 0.9 120n 0.9 129.5n 0.9 130n 0 139.5n 0]
Vth151 (th151 0) vsource type=pwl wave=[0 0 9.5n 0 10n 0 19.5n 0 20n 0 29.5n 0 30n 0 39.5n 0 40n 0 49.5n 0 50n 0 59.5n 0 60n 0 69.5n 0 70n 0 79.5n 0 80n 0 89.5n 0 90n 0 99.5n 0 100n 0 109.5n 0 110n 0.9 119.5n 0.9 120n 0.9 129.5n 0.9 130n 0 139.5n 0]
Vth152 (th152 0) vsource type=pwl wave=[0 0 9.5n 0 10n 0 19.5n 0 20n 0 29.5n 0 30n 0 39.5n 0 40n 0 49.5n 0 50n 0 59.5n 0 60n 0 69.5n 0 70n 0 79.5n 0 80n 0 89.5n 0 90n 0 99.5n 0 100n 0 109.5n 0 110n 0.9 119.5n 0.9 120n 0.9 129.5n 0.9 130n 0 139.5n 0]
Vth153 (th153 0) vsource type=pwl wave=[0 0 9.5n 0 10n 0 19.5n 0 20n 0 29.5n 0 30n 0 39.5n 0 40n 0 49.5n 0 50n 0 59.5n 0 60n 0 69.5n 0 70n 0 79.5n 0 80n 0 89.5n 0 90n 0 99.5n 0 100n 0 109.5n 0 110n 0.9 119.5n 0.9 120n 0.9 129.5n 0.9 130n 0 139.5n 0]
Vth154 (th154 0) vsource type=pwl wave=[0 0 9.5n 0 10n 0 19.5n 0 20n 0 29.5n 0 30n 0 39.5n 0 40n 0 49.5n 0 50n 0 59.5n 0 60n 0 69.5n 0 70n 0 79.5n 0 80n 0 89.5n 0 90n 0 99.5n 0 100n 0 109.5n 0 110n 0.9 119.5n 0.9 120n 0.9 129.5n 0.9 130n 0 139.5n 0]
Vth155 (th155 0) vsource type=pwl wave=[0 0 9.5n 0 10n 0 19.5n 0 20n 0 29.5n 0 30n 0 39.5n 0 40n 0 49.5n 0 50n 0 59.5n 0 60n 0 69.5n 0 70n 0 79.5n 0 80n 0 89.5n 0 90n 0 99.5n 0 100n 0 109.5n 0 110n 0.9 119.5n 0.9 120n 0.9 129.5n 0.9 130n 0 139.5n 0]
Vth156 (th156 0) vsource type=pwl wave=[0 0 9.5n 0 10n 0 19.5n 0 20n 0 29.5n 0 30n 0 39.5n 0 40n 0 49.5n 0 50n 0 59.5n 0 60n 0 69.5n 0 70n 0 79.5n 0 80n 0 89.5n 0 90n 0 99.5n 0 100n 0 109.5n 0 110n 0.9 119.5n 0.9 120n 0.9 129.5n 0.9 130n 0 139.5n 0]
Vth157 (th157 0) vsource type=pwl wave=[0 0 9.5n 0 10n 0 19.5n 0 20n 0 29.5n 0 30n 0 39.5n 0 40n 0 49.5n 0 50n 0 59.5n 0 60n 0 69.5n 0 70n 0 79.5n 0 80n 0 89.5n 0 90n 0 99.5n 0 100n 0 109.5n 0 110n 0.9 119.5n 0.9 120n 0.9 129.5n 0.9 130n 0 139.5n 0]
Vth158 (th158 0) vsource type=pwl wave=[0 0 9.5n 0 10n 0 19.5n 0 20n 0 29.5n 0 30n 0 39.5n 0 40n 0 49.5n 0 50n 0 59.5n 0 60n 0 69.5n 0 70n 0 79.5n 0 80n 0 89.5n 0 90n 0 99.5n 0 100n 0 109.5n 0 110n 0.9 119.5n 0.9 120n 0.9 129.5n 0.9 130n 0 139.5n 0]
Vth159 (th159 0) vsource type=pwl wave=[0 0 9.5n 0 10n 0 19.5n 0 20n 0 29.5n 0 30n 0 39.5n 0 40n 0 49.5n 0 50n 0 59.5n 0 60n 0 69.5n 0 70n 0 79.5n 0 80n 0 89.5n 0 90n 0 99.5n 0 100n 0 109.5n 0 110n 0.9 119.5n 0.9 120n 0.9 129.5n 0.9 130n 0 139.5n 0]
Vth160 (th160 0) vsource type=pwl wave=[0 0 9.5n 0 10n 0 19.5n 0 20n 0 29.5n 0 30n 0 39.5n 0 40n 0 49.5n 0 50n 0 59.5n 0 60n 0 69.5n 0 70n 0 79.5n 0 80n 0 89.5n 0 90n 0 99.5n 0 100n 0 109.5n 0 110n 0.9 119.5n 0.9 120n 0.9 129.5n 0.9 130n 0 139.5n 0]
Vth161 (th161 0) vsource type=pwl wave=[0 0 9.5n 0 10n 0 19.5n 0 20n 0 29.5n 0 30n 0 39.5n 0 40n 0 49.5n 0 50n 0 59.5n 0 60n 0 69.5n 0 70n 0 79.5n 0 80n 0 89.5n 0 90n 0 99.5n 0 100n 0 109.5n 0 110n 0.9 119.5n 0.9 120n 0.9 129.5n 0.9 130n 0 139.5n 0]
Vth162 (th162 0) vsource type=pwl wave=[0 0 9.5n 0 10n 0 19.5n 0 20n 0 29.5n 0 30n 0 39.5n 0 40n 0 49.5n 0 50n 0 59.5n 0 60n 0 69.5n 0 70n 0 79.5n 0 80n 0 89.5n 0 90n 0 99.5n 0 100n 0 109.5n 0 110n 0.9 119.5n 0.9 120n 0.9 129.5n 0.9 130n 0 139.5n 0]
Vth163 (th163 0) vsource type=pwl wave=[0 0 9.5n 0 10n 0 19.5n 0 20n 0 29.5n 0 30n 0 39.5n 0 40n 0 49.5n 0 50n 0 59.5n 0 60n 0 69.5n 0 70n 0 79.5n 0 80n 0 89.5n 0 90n 0 99.5n 0 100n 0 109.5n 0 110n 0.9 119.5n 0.9 120n 0.9 129.5n 0.9 130n 0 139.5n 0]
Vth164 (th164 0) vsource type=pwl wave=[0 0 9.5n 0 10n 0 19.5n 0 20n 0 29.5n 0 30n 0 39.5n 0 40n 0 49.5n 0 50n 0 59.5n 0 60n 0 69.5n 0 70n 0 79.5n 0 80n 0 89.5n 0 90n 0 99.5n 0 100n 0 109.5n 0 110n 0.9 119.5n 0.9 120n 0.9 129.5n 0.9 130n 0 139.5n 0]
Vth165 (th165 0) vsource type=pwl wave=[0 0 9.5n 0 10n 0 19.5n 0 20n 0 29.5n 0 30n 0 39.5n 0 40n 0 49.5n 0 50n 0 59.5n 0 60n 0 69.5n 0 70n 0 79.5n 0 80n 0 89.5n 0 90n 0 99.5n 0 100n 0 109.5n 0 110n 0.9 119.5n 0.9 120n 0.9 129.5n 0.9 130n 0 139.5n 0]
Vth166 (th166 0) vsource type=pwl wave=[0 0 9.5n 0 10n 0 19.5n 0 20n 0 29.5n 0 30n 0 39.5n 0 40n 0 49.5n 0 50n 0 59.5n 0 60n 0 69.5n 0 70n 0 79.5n 0 80n 0 89.5n 0 90n 0 99.5n 0 100n 0 109.5n 0 110n 0.9 119.5n 0.9 120n 0.9 129.5n 0.9 130n 0 139.5n 0]
Vth167 (th167 0) vsource type=pwl wave=[0 0 9.5n 0 10n 0 19.5n 0 20n 0 29.5n 0 30n 0 39.5n 0 40n 0 49.5n 0 50n 0 59.5n 0 60n 0 69.5n 0 70n 0 79.5n 0 80n 0 89.5n 0 90n 0 99.5n 0 100n 0 109.5n 0 110n 0.9 119.5n 0.9 120n 0.9 129.5n 0.9 130n 0 139.5n 0]
Vth168 (th168 0) vsource type=pwl wave=[0 0 9.5n 0 10n 0 19.5n 0 20n 0 29.5n 0 30n 0 39.5n 0 40n 0 49.5n 0 50n 0 59.5n 0 60n 0 69.5n 0 70n 0 79.5n 0 80n 0 89.5n 0 90n 0 99.5n 0 100n 0 109.5n 0 110n 0.9 119.5n 0.9 120n 0.9 129.5n 0.9 130n 0 139.5n 0]
Vth169 (th169 0) vsource type=pwl wave=[0 0 9.5n 0 10n 0 19.5n 0 20n 0 29.5n 0 30n 0 39.5n 0 40n 0 49.5n 0 50n 0 59.5n 0 60n 0 69.5n 0 70n 0 79.5n 0 80n 0 89.5n 0 90n 0 99.5n 0 100n 0 109.5n 0 110n 0.9 119.5n 0.9 120n 0.9 129.5n 0.9 130n 0 139.5n 0]
Vth170 (th170 0) vsource type=pwl wave=[0 0 9.5n 0 10n 0 19.5n 0 20n 0 29.5n 0 30n 0 39.5n 0 40n 0 49.5n 0 50n 0 59.5n 0 60n 0 69.5n 0 70n 0 79.5n 0 80n 0 89.5n 0 90n 0 99.5n 0 100n 0 109.5n 0 110n 0.9 119.5n 0.9 120n 0.9 129.5n 0.9 130n 0 139.5n 0]
Vth171 (th171 0) vsource type=pwl wave=[0 0 9.5n 0 10n 0 19.5n 0 20n 0 29.5n 0 30n 0 39.5n 0 40n 0 49.5n 0 50n 0 59.5n 0 60n 0 69.5n 0 70n 0 79.5n 0 80n 0 89.5n 0 90n 0 99.5n 0 100n 0 109.5n 0 110n 0.9 119.5n 0.9 120n 0.9 129.5n 0.9 130n 0 139.5n 0]
Vth172 (th172 0) vsource type=pwl wave=[0 0 9.5n 0 10n 0 19.5n 0 20n 0 29.5n 0 30n 0 39.5n 0 40n 0 49.5n 0 50n 0 59.5n 0 60n 0 69.5n 0 70n 0 79.5n 0 80n 0 89.5n 0 90n 0 99.5n 0 100n 0 109.5n 0 110n 0.9 119.5n 0.9 120n 0.9 129.5n 0.9 130n 0 139.5n 0]
Vth173 (th173 0) vsource type=pwl wave=[0 0 9.5n 0 10n 0 19.5n 0 20n 0 29.5n 0 30n 0 39.5n 0 40n 0 49.5n 0 50n 0 59.5n 0 60n 0 69.5n 0 70n 0 79.5n 0 80n 0 89.5n 0 90n 0 99.5n 0 100n 0 109.5n 0 110n 0.9 119.5n 0.9 120n 0.9 129.5n 0.9 130n 0 139.5n 0]
Vth174 (th174 0) vsource type=pwl wave=[0 0 9.5n 0 10n 0 19.5n 0 20n 0 29.5n 0 30n 0 39.5n 0 40n 0 49.5n 0 50n 0 59.5n 0 60n 0 69.5n 0 70n 0 79.5n 0 80n 0 89.5n 0 90n 0 99.5n 0 100n 0 109.5n 0 110n 0.9 119.5n 0.9 120n 0.9 129.5n 0.9 130n 0 139.5n 0]
Vth175 (th175 0) vsource type=pwl wave=[0 0 9.5n 0 10n 0 19.5n 0 20n 0 29.5n 0 30n 0 39.5n 0 40n 0 49.5n 0 50n 0 59.5n 0 60n 0 69.5n 0 70n 0 79.5n 0 80n 0 89.5n 0 90n 0 99.5n 0 100n 0 109.5n 0 110n 0.9 119.5n 0.9 120n 0.9 129.5n 0.9 130n 0 139.5n 0]
Vth176 (th176 0) vsource type=pwl wave=[0 0 9.5n 0 10n 0 19.5n 0 20n 0 29.5n 0 30n 0 39.5n 0 40n 0 49.5n 0 50n 0 59.5n 0 60n 0 69.5n 0 70n 0 79.5n 0 80n 0 89.5n 0 90n 0 99.5n 0 100n 0 109.5n 0 110n 0.9 119.5n 0.9 120n 0.9 129.5n 0.9 130n 0 139.5n 0]
Vth177 (th177 0) vsource type=pwl wave=[0 0 9.5n 0 10n 0 19.5n 0 20n 0 29.5n 0 30n 0 39.5n 0 40n 0 49.5n 0 50n 0 59.5n 0 60n 0 69.5n 0 70n 0 79.5n 0 80n 0 89.5n 0 90n 0 99.5n 0 100n 0 109.5n 0 110n 0.9 119.5n 0.9 120n 0.9 129.5n 0.9 130n 0 139.5n 0]
Vth178 (th178 0) vsource type=pwl wave=[0 0 9.5n 0 10n 0 19.5n 0 20n 0 29.5n 0 30n 0 39.5n 0 40n 0 49.5n 0 50n 0 59.5n 0 60n 0 69.5n 0 70n 0 79.5n 0 80n 0 89.5n 0 90n 0 99.5n 0 100n 0 109.5n 0 110n 0.9 119.5n 0.9 120n 0.9 129.5n 0.9 130n 0 139.5n 0]
Vth179 (th179 0) vsource type=pwl wave=[0 0 9.5n 0 10n 0 19.5n 0 20n 0 29.5n 0 30n 0 39.5n 0 40n 0 49.5n 0 50n 0 59.5n 0 60n 0 69.5n 0 70n 0 79.5n 0 80n 0 89.5n 0 90n 0 99.5n 0 100n 0 109.5n 0 110n 0.9 119.5n 0.9 120n 0.9 129.5n 0.9 130n 0 139.5n 0]
Vth180 (th180 0) vsource type=pwl wave=[0 0 9.5n 0 10n 0 19.5n 0 20n 0 29.5n 0 30n 0 39.5n 0 40n 0 49.5n 0 50n 0 59.5n 0 60n 0 69.5n 0 70n 0 79.5n 0 80n 0 89.5n 0 90n 0 99.5n 0 100n 0 109.5n 0 110n 0.9 119.5n 0.9 120n 0.9 129.5n 0.9 130n 0 139.5n 0]
Vth181 (th181 0) vsource type=pwl wave=[0 0 9.5n 0 10n 0 19.5n 0 20n 0 29.5n 0 30n 0 39.5n 0 40n 0 49.5n 0 50n 0 59.5n 0 60n 0 69.5n 0 70n 0 79.5n 0 80n 0 89.5n 0 90n 0 99.5n 0 100n 0 109.5n 0 110n 0.9 119.5n 0.9 120n 0.9 129.5n 0.9 130n 0 139.5n 0]
Vth182 (th182 0) vsource type=pwl wave=[0 0 9.5n 0 10n 0 19.5n 0 20n 0 29.5n 0 30n 0 39.5n 0 40n 0 49.5n 0 50n 0 59.5n 0 60n 0 69.5n 0 70n 0 79.5n 0 80n 0 89.5n 0 90n 0 99.5n 0 100n 0 109.5n 0 110n 0.9 119.5n 0.9 120n 0.9 129.5n 0.9 130n 0 139.5n 0]
Vth183 (th183 0) vsource type=pwl wave=[0 0 9.5n 0 10n 0 19.5n 0 20n 0 29.5n 0 30n 0 39.5n 0 40n 0 49.5n 0 50n 0 59.5n 0 60n 0 69.5n 0 70n 0 79.5n 0 80n 0 89.5n 0 90n 0 99.5n 0 100n 0 109.5n 0 110n 0.9 119.5n 0.9 120n 0.9 129.5n 0.9 130n 0 139.5n 0]
Vth184 (th184 0) vsource type=pwl wave=[0 0 9.5n 0 10n 0 19.5n 0 20n 0 29.5n 0 30n 0 39.5n 0 40n 0 49.5n 0 50n 0 59.5n 0 60n 0 69.5n 0 70n 0 79.5n 0 80n 0 89.5n 0 90n 0 99.5n 0 100n 0 109.5n 0 110n 0.9 119.5n 0.9 120n 0.9 129.5n 0.9 130n 0 139.5n 0]
Vth185 (th185 0) vsource type=pwl wave=[0 0 9.5n 0 10n 0 19.5n 0 20n 0 29.5n 0 30n 0 39.5n 0 40n 0 49.5n 0 50n 0 59.5n 0 60n 0 69.5n 0 70n 0 79.5n 0 80n 0 89.5n 0 90n 0 99.5n 0 100n 0 109.5n 0 110n 0.9 119.5n 0.9 120n 0.9 129.5n 0.9 130n 0 139.5n 0]
Vth186 (th186 0) vsource type=pwl wave=[0 0 9.5n 0 10n 0 19.5n 0 20n 0 29.5n 0 30n 0 39.5n 0 40n 0 49.5n 0 50n 0 59.5n 0 60n 0 69.5n 0 70n 0 79.5n 0 80n 0 89.5n 0 90n 0 99.5n 0 100n 0 109.5n 0 110n 0.9 119.5n 0.9 120n 0.9 129.5n 0.9 130n 0 139.5n 0]
Vth187 (th187 0) vsource type=pwl wave=[0 0 9.5n 0 10n 0 19.5n 0 20n 0 29.5n 0 30n 0 39.5n 0 40n 0 49.5n 0 50n 0 59.5n 0 60n 0 69.5n 0 70n 0 79.5n 0 80n 0 89.5n 0 90n 0 99.5n 0 100n 0 109.5n 0 110n 0.9 119.5n 0.9 120n 0.9 129.5n 0.9 130n 0 139.5n 0]
Vth188 (th188 0) vsource type=pwl wave=[0 0 9.5n 0 10n 0 19.5n 0 20n 0 29.5n 0 30n 0 39.5n 0 40n 0 49.5n 0 50n 0 59.5n 0 60n 0 69.5n 0 70n 0 79.5n 0 80n 0 89.5n 0 90n 0 99.5n 0 100n 0 109.5n 0 110n 0.9 119.5n 0.9 120n 0.9 129.5n 0.9 130n 0 139.5n 0]
Vth189 (th189 0) vsource type=pwl wave=[0 0 9.5n 0 10n 0 19.5n 0 20n 0 29.5n 0 30n 0 39.5n 0 40n 0 49.5n 0 50n 0 59.5n 0 60n 0 69.5n 0 70n 0 79.5n 0 80n 0 89.5n 0 90n 0 99.5n 0 100n 0 109.5n 0 110n 0.9 119.5n 0.9 120n 0.9 129.5n 0.9 130n 0 139.5n 0]
Vth190 (th190 0) vsource type=pwl wave=[0 0 9.5n 0 10n 0 19.5n 0 20n 0 29.5n 0 30n 0 39.5n 0 40n 0 49.5n 0 50n 0 59.5n 0 60n 0 69.5n 0 70n 0 79.5n 0 80n 0 89.5n 0 90n 0 99.5n 0 100n 0 109.5n 0 110n 0.9 119.5n 0.9 120n 0.9 129.5n 0.9 130n 0 139.5n 0]
Vth191 (th191 0) vsource type=pwl wave=[0 0 9.5n 0 10n 0 19.5n 0 20n 0 29.5n 0 30n 0 39.5n 0 40n 0 49.5n 0 50n 0 59.5n 0 60n 0 69.5n 0 70n 0 79.5n 0 80n 0 89.5n 0 90n 0 99.5n 0 100n 0 109.5n 0 110n 0.9 119.5n 0.9 120n 0.9 129.5n 0.9 130n 0 139.5n 0]
Vth192 (th192 0) vsource type=pwl wave=[0 0 9.5n 0 10n 0 19.5n 0 20n 0 29.5n 0 30n 0 39.5n 0 40n 0 49.5n 0 50n 0 59.5n 0 60n 0 69.5n 0 70n 0 79.5n 0 80n 0 89.5n 0 90n 0 99.5n 0 100n 0 109.5n 0 110n 0.9 119.5n 0.9 120n 0.9 129.5n 0.9 130n 0 139.5n 0]
Vth193 (th193 0) vsource type=pwl wave=[0 0 9.5n 0 10n 0 19.5n 0 20n 0 29.5n 0 30n 0 39.5n 0 40n 0 49.5n 0 50n 0 59.5n 0 60n 0 69.5n 0 70n 0 79.5n 0 80n 0 89.5n 0 90n 0 99.5n 0 100n 0 109.5n 0 110n 0.9 119.5n 0.9 120n 0.9 129.5n 0.9 130n 0 139.5n 0]
Vth194 (th194 0) vsource type=pwl wave=[0 0 9.5n 0 10n 0 19.5n 0 20n 0 29.5n 0 30n 0 39.5n 0 40n 0 49.5n 0 50n 0 59.5n 0 60n 0 69.5n 0 70n 0 79.5n 0 80n 0 89.5n 0 90n 0 99.5n 0 100n 0 109.5n 0 110n 0.9 119.5n 0.9 120n 0.9 129.5n 0.9 130n 0 139.5n 0]
Vth195 (th195 0) vsource type=pwl wave=[0 0 9.5n 0 10n 0 19.5n 0 20n 0 29.5n 0 30n 0 39.5n 0 40n 0 49.5n 0 50n 0 59.5n 0 60n 0 69.5n 0 70n 0 79.5n 0 80n 0 89.5n 0 90n 0 99.5n 0 100n 0 109.5n 0 110n 0.9 119.5n 0.9 120n 0.9 129.5n 0.9 130n 0 139.5n 0]
Vth196 (th196 0) vsource type=pwl wave=[0 0 9.5n 0 10n 0 19.5n 0 20n 0 29.5n 0 30n 0 39.5n 0 40n 0 49.5n 0 50n 0 59.5n 0 60n 0 69.5n 0 70n 0 79.5n 0 80n 0 89.5n 0 90n 0 99.5n 0 100n 0 109.5n 0 110n 0.9 119.5n 0.9 120n 0.9 129.5n 0.9 130n 0 139.5n 0]
Vth197 (th197 0) vsource type=pwl wave=[0 0 9.5n 0 10n 0 19.5n 0 20n 0 29.5n 0 30n 0 39.5n 0 40n 0 49.5n 0 50n 0 59.5n 0 60n 0 69.5n 0 70n 0 79.5n 0 80n 0 89.5n 0 90n 0 99.5n 0 100n 0 109.5n 0 110n 0.9 119.5n 0.9 120n 0.9 129.5n 0.9 130n 0 139.5n 0]
Vth198 (th198 0) vsource type=pwl wave=[0 0 9.5n 0 10n 0 19.5n 0 20n 0 29.5n 0 30n 0 39.5n 0 40n 0 49.5n 0 50n 0 59.5n 0 60n 0 69.5n 0 70n 0 79.5n 0 80n 0 89.5n 0 90n 0 99.5n 0 100n 0 109.5n 0 110n 0.9 119.5n 0.9 120n 0.9 129.5n 0.9 130n 0 139.5n 0]
Vth199 (th199 0) vsource type=pwl wave=[0 0 9.5n 0 10n 0 19.5n 0 20n 0 29.5n 0 30n 0 39.5n 0 40n 0 49.5n 0 50n 0 59.5n 0 60n 0 69.5n 0 70n 0 79.5n 0 80n 0 89.5n 0 90n 0 99.5n 0 100n 0 109.5n 0 110n 0.9 119.5n 0.9 120n 0.9 129.5n 0.9 130n 0 139.5n 0]
Vth200 (th200 0) vsource type=pwl wave=[0 0 9.5n 0 10n 0 19.5n 0 20n 0 29.5n 0 30n 0 39.5n 0 40n 0 49.5n 0 50n 0 59.5n 0 60n 0 69.5n 0 70n 0 79.5n 0 80n 0 89.5n 0 90n 0 99.5n 0 100n 0 109.5n 0 110n 0 119.5n 0 120n 0.9 129.5n 0.9 130n 0 139.5n 0]
Vth201 (th201 0) vsource type=pwl wave=[0 0 9.5n 0 10n 0 19.5n 0 20n 0 29.5n 0 30n 0 39.5n 0 40n 0 49.5n 0 50n 0 59.5n 0 60n 0 69.5n 0 70n 0 79.5n 0 80n 0 89.5n 0 90n 0 99.5n 0 100n 0 109.5n 0 110n 0 119.5n 0 120n 0.9 129.5n 0.9 130n 0 139.5n 0]
Vth202 (th202 0) vsource type=pwl wave=[0 0 9.5n 0 10n 0 19.5n 0 20n 0 29.5n 0 30n 0 39.5n 0 40n 0 49.5n 0 50n 0 59.5n 0 60n 0 69.5n 0 70n 0 79.5n 0 80n 0 89.5n 0 90n 0 99.5n 0 100n 0 109.5n 0 110n 0 119.5n 0 120n 0.9 129.5n 0.9 130n 0 139.5n 0]
Vth203 (th203 0) vsource type=pwl wave=[0 0 9.5n 0 10n 0 19.5n 0 20n 0 29.5n 0 30n 0 39.5n 0 40n 0 49.5n 0 50n 0 59.5n 0 60n 0 69.5n 0 70n 0 79.5n 0 80n 0 89.5n 0 90n 0 99.5n 0 100n 0 109.5n 0 110n 0 119.5n 0 120n 0.9 129.5n 0.9 130n 0 139.5n 0]
Vth204 (th204 0) vsource type=pwl wave=[0 0 9.5n 0 10n 0 19.5n 0 20n 0 29.5n 0 30n 0 39.5n 0 40n 0 49.5n 0 50n 0 59.5n 0 60n 0 69.5n 0 70n 0 79.5n 0 80n 0 89.5n 0 90n 0 99.5n 0 100n 0 109.5n 0 110n 0 119.5n 0 120n 0.9 129.5n 0.9 130n 0 139.5n 0]
Vth205 (th205 0) vsource type=pwl wave=[0 0 9.5n 0 10n 0 19.5n 0 20n 0 29.5n 0 30n 0 39.5n 0 40n 0 49.5n 0 50n 0 59.5n 0 60n 0 69.5n 0 70n 0 79.5n 0 80n 0 89.5n 0 90n 0 99.5n 0 100n 0 109.5n 0 110n 0 119.5n 0 120n 0.9 129.5n 0.9 130n 0 139.5n 0]
Vth206 (th206 0) vsource type=pwl wave=[0 0 9.5n 0 10n 0 19.5n 0 20n 0 29.5n 0 30n 0 39.5n 0 40n 0 49.5n 0 50n 0 59.5n 0 60n 0 69.5n 0 70n 0 79.5n 0 80n 0 89.5n 0 90n 0 99.5n 0 100n 0 109.5n 0 110n 0 119.5n 0 120n 0.9 129.5n 0.9 130n 0 139.5n 0]
Vth207 (th207 0) vsource type=pwl wave=[0 0 9.5n 0 10n 0 19.5n 0 20n 0 29.5n 0 30n 0 39.5n 0 40n 0 49.5n 0 50n 0 59.5n 0 60n 0 69.5n 0 70n 0 79.5n 0 80n 0 89.5n 0 90n 0 99.5n 0 100n 0 109.5n 0 110n 0 119.5n 0 120n 0.9 129.5n 0.9 130n 0 139.5n 0]
Vth208 (th208 0) vsource type=pwl wave=[0 0 9.5n 0 10n 0 19.5n 0 20n 0 29.5n 0 30n 0 39.5n 0 40n 0 49.5n 0 50n 0 59.5n 0 60n 0 69.5n 0 70n 0 79.5n 0 80n 0 89.5n 0 90n 0 99.5n 0 100n 0 109.5n 0 110n 0 119.5n 0 120n 0.9 129.5n 0.9 130n 0 139.5n 0]
Vth209 (th209 0) vsource type=pwl wave=[0 0 9.5n 0 10n 0 19.5n 0 20n 0 29.5n 0 30n 0 39.5n 0 40n 0 49.5n 0 50n 0 59.5n 0 60n 0 69.5n 0 70n 0 79.5n 0 80n 0 89.5n 0 90n 0 99.5n 0 100n 0 109.5n 0 110n 0 119.5n 0 120n 0.9 129.5n 0.9 130n 0 139.5n 0]
Vth210 (th210 0) vsource type=pwl wave=[0 0 9.5n 0 10n 0 19.5n 0 20n 0 29.5n 0 30n 0 39.5n 0 40n 0 49.5n 0 50n 0 59.5n 0 60n 0 69.5n 0 70n 0 79.5n 0 80n 0 89.5n 0 90n 0 99.5n 0 100n 0 109.5n 0 110n 0 119.5n 0 120n 0.9 129.5n 0.9 130n 0 139.5n 0]
Vth211 (th211 0) vsource type=pwl wave=[0 0 9.5n 0 10n 0 19.5n 0 20n 0 29.5n 0 30n 0 39.5n 0 40n 0 49.5n 0 50n 0 59.5n 0 60n 0 69.5n 0 70n 0 79.5n 0 80n 0 89.5n 0 90n 0 99.5n 0 100n 0 109.5n 0 110n 0 119.5n 0 120n 0.9 129.5n 0.9 130n 0 139.5n 0]
Vth212 (th212 0) vsource type=pwl wave=[0 0 9.5n 0 10n 0 19.5n 0 20n 0 29.5n 0 30n 0 39.5n 0 40n 0 49.5n 0 50n 0 59.5n 0 60n 0 69.5n 0 70n 0 79.5n 0 80n 0 89.5n 0 90n 0 99.5n 0 100n 0 109.5n 0 110n 0 119.5n 0 120n 0.9 129.5n 0.9 130n 0 139.5n 0]
Vth213 (th213 0) vsource type=pwl wave=[0 0 9.5n 0 10n 0 19.5n 0 20n 0 29.5n 0 30n 0 39.5n 0 40n 0 49.5n 0 50n 0 59.5n 0 60n 0 69.5n 0 70n 0 79.5n 0 80n 0 89.5n 0 90n 0 99.5n 0 100n 0 109.5n 0 110n 0 119.5n 0 120n 0.9 129.5n 0.9 130n 0 139.5n 0]
Vth214 (th214 0) vsource type=pwl wave=[0 0 9.5n 0 10n 0 19.5n 0 20n 0 29.5n 0 30n 0 39.5n 0 40n 0 49.5n 0 50n 0 59.5n 0 60n 0 69.5n 0 70n 0 79.5n 0 80n 0 89.5n 0 90n 0 99.5n 0 100n 0 109.5n 0 110n 0 119.5n 0 120n 0.9 129.5n 0.9 130n 0 139.5n 0]
Vth215 (th215 0) vsource type=pwl wave=[0 0 9.5n 0 10n 0 19.5n 0 20n 0 29.5n 0 30n 0 39.5n 0 40n 0 49.5n 0 50n 0 59.5n 0 60n 0 69.5n 0 70n 0 79.5n 0 80n 0 89.5n 0 90n 0 99.5n 0 100n 0 109.5n 0 110n 0 119.5n 0 120n 0.9 129.5n 0.9 130n 0 139.5n 0]
Vth216 (th216 0) vsource type=pwl wave=[0 0 9.5n 0 10n 0 19.5n 0 20n 0 29.5n 0 30n 0 39.5n 0 40n 0 49.5n 0 50n 0 59.5n 0 60n 0 69.5n 0 70n 0 79.5n 0 80n 0 89.5n 0 90n 0 99.5n 0 100n 0 109.5n 0 110n 0 119.5n 0 120n 0.9 129.5n 0.9 130n 0 139.5n 0]
Vth217 (th217 0) vsource type=pwl wave=[0 0 9.5n 0 10n 0 19.5n 0 20n 0 29.5n 0 30n 0 39.5n 0 40n 0 49.5n 0 50n 0 59.5n 0 60n 0 69.5n 0 70n 0 79.5n 0 80n 0 89.5n 0 90n 0 99.5n 0 100n 0 109.5n 0 110n 0 119.5n 0 120n 0.9 129.5n 0.9 130n 0 139.5n 0]
Vth218 (th218 0) vsource type=pwl wave=[0 0 9.5n 0 10n 0 19.5n 0 20n 0 29.5n 0 30n 0 39.5n 0 40n 0 49.5n 0 50n 0 59.5n 0 60n 0 69.5n 0 70n 0 79.5n 0 80n 0 89.5n 0 90n 0 99.5n 0 100n 0 109.5n 0 110n 0 119.5n 0 120n 0.9 129.5n 0.9 130n 0 139.5n 0]
Vth219 (th219 0) vsource type=pwl wave=[0 0 9.5n 0 10n 0 19.5n 0 20n 0 29.5n 0 30n 0 39.5n 0 40n 0 49.5n 0 50n 0 59.5n 0 60n 0 69.5n 0 70n 0 79.5n 0 80n 0 89.5n 0 90n 0 99.5n 0 100n 0 109.5n 0 110n 0 119.5n 0 120n 0.9 129.5n 0.9 130n 0 139.5n 0]
Vth220 (th220 0) vsource type=pwl wave=[0 0 9.5n 0 10n 0 19.5n 0 20n 0 29.5n 0 30n 0 39.5n 0 40n 0 49.5n 0 50n 0 59.5n 0 60n 0 69.5n 0 70n 0 79.5n 0 80n 0 89.5n 0 90n 0 99.5n 0 100n 0 109.5n 0 110n 0 119.5n 0 120n 0.9 129.5n 0.9 130n 0 139.5n 0]
Vth221 (th221 0) vsource type=pwl wave=[0 0 9.5n 0 10n 0 19.5n 0 20n 0 29.5n 0 30n 0 39.5n 0 40n 0 49.5n 0 50n 0 59.5n 0 60n 0 69.5n 0 70n 0 79.5n 0 80n 0 89.5n 0 90n 0 99.5n 0 100n 0 109.5n 0 110n 0 119.5n 0 120n 0.9 129.5n 0.9 130n 0 139.5n 0]
Vth222 (th222 0) vsource type=pwl wave=[0 0 9.5n 0 10n 0 19.5n 0 20n 0 29.5n 0 30n 0 39.5n 0 40n 0 49.5n 0 50n 0 59.5n 0 60n 0 69.5n 0 70n 0 79.5n 0 80n 0 89.5n 0 90n 0 99.5n 0 100n 0 109.5n 0 110n 0 119.5n 0 120n 0.9 129.5n 0.9 130n 0 139.5n 0]
Vth223 (th223 0) vsource type=pwl wave=[0 0 9.5n 0 10n 0 19.5n 0 20n 0 29.5n 0 30n 0 39.5n 0 40n 0 49.5n 0 50n 0 59.5n 0 60n 0 69.5n 0 70n 0 79.5n 0 80n 0 89.5n 0 90n 0 99.5n 0 100n 0 109.5n 0 110n 0 119.5n 0 120n 0.9 129.5n 0.9 130n 0 139.5n 0]
Vth224 (th224 0) vsource type=pwl wave=[0 0 9.5n 0 10n 0 19.5n 0 20n 0 29.5n 0 30n 0 39.5n 0 40n 0 49.5n 0 50n 0 59.5n 0 60n 0 69.5n 0 70n 0 79.5n 0 80n 0 89.5n 0 90n 0 99.5n 0 100n 0 109.5n 0 110n 0 119.5n 0 120n 0.9 129.5n 0.9 130n 0 139.5n 0]
Vth225 (th225 0) vsource type=pwl wave=[0 0 9.5n 0 10n 0 19.5n 0 20n 0 29.5n 0 30n 0 39.5n 0 40n 0 49.5n 0 50n 0 59.5n 0 60n 0 69.5n 0 70n 0 79.5n 0 80n 0 89.5n 0 90n 0 99.5n 0 100n 0 109.5n 0 110n 0 119.5n 0 120n 0.9 129.5n 0.9 130n 0 139.5n 0]
Vth226 (th226 0) vsource type=pwl wave=[0 0 9.5n 0 10n 0 19.5n 0 20n 0 29.5n 0 30n 0 39.5n 0 40n 0 49.5n 0 50n 0 59.5n 0 60n 0 69.5n 0 70n 0 79.5n 0 80n 0 89.5n 0 90n 0 99.5n 0 100n 0 109.5n 0 110n 0 119.5n 0 120n 0.9 129.5n 0.9 130n 0 139.5n 0]
Vth227 (th227 0) vsource type=pwl wave=[0 0 9.5n 0 10n 0 19.5n 0 20n 0 29.5n 0 30n 0 39.5n 0 40n 0 49.5n 0 50n 0 59.5n 0 60n 0 69.5n 0 70n 0 79.5n 0 80n 0 89.5n 0 90n 0 99.5n 0 100n 0 109.5n 0 110n 0 119.5n 0 120n 0.9 129.5n 0.9 130n 0 139.5n 0]
Vth228 (th228 0) vsource type=pwl wave=[0 0 9.5n 0 10n 0 19.5n 0 20n 0 29.5n 0 30n 0 39.5n 0 40n 0 49.5n 0 50n 0 59.5n 0 60n 0 69.5n 0 70n 0 79.5n 0 80n 0 89.5n 0 90n 0 99.5n 0 100n 0 109.5n 0 110n 0 119.5n 0 120n 0.9 129.5n 0.9 130n 0 139.5n 0]
Vth229 (th229 0) vsource type=pwl wave=[0 0 9.5n 0 10n 0 19.5n 0 20n 0 29.5n 0 30n 0 39.5n 0 40n 0 49.5n 0 50n 0 59.5n 0 60n 0 69.5n 0 70n 0 79.5n 0 80n 0 89.5n 0 90n 0 99.5n 0 100n 0 109.5n 0 110n 0 119.5n 0 120n 0.9 129.5n 0.9 130n 0 139.5n 0]
Vth230 (th230 0) vsource type=pwl wave=[0 0 9.5n 0 10n 0 19.5n 0 20n 0 29.5n 0 30n 0 39.5n 0 40n 0 49.5n 0 50n 0 59.5n 0 60n 0 69.5n 0 70n 0 79.5n 0 80n 0 89.5n 0 90n 0 99.5n 0 100n 0 109.5n 0 110n 0 119.5n 0 120n 0.9 129.5n 0.9 130n 0 139.5n 0]
Vth231 (th231 0) vsource type=pwl wave=[0 0 9.5n 0 10n 0 19.5n 0 20n 0 29.5n 0 30n 0 39.5n 0 40n 0 49.5n 0 50n 0 59.5n 0 60n 0 69.5n 0 70n 0 79.5n 0 80n 0 89.5n 0 90n 0 99.5n 0 100n 0 109.5n 0 110n 0 119.5n 0 120n 0.9 129.5n 0.9 130n 0 139.5n 0]
Vth232 (th232 0) vsource type=pwl wave=[0 0 9.5n 0 10n 0 19.5n 0 20n 0 29.5n 0 30n 0 39.5n 0 40n 0 49.5n 0 50n 0 59.5n 0 60n 0 69.5n 0 70n 0 79.5n 0 80n 0 89.5n 0 90n 0 99.5n 0 100n 0 109.5n 0 110n 0 119.5n 0 120n 0.9 129.5n 0.9 130n 0 139.5n 0]
Vth233 (th233 0) vsource type=pwl wave=[0 0 9.5n 0 10n 0 19.5n 0 20n 0 29.5n 0 30n 0 39.5n 0 40n 0 49.5n 0 50n 0 59.5n 0 60n 0 69.5n 0 70n 0 79.5n 0 80n 0 89.5n 0 90n 0 99.5n 0 100n 0 109.5n 0 110n 0 119.5n 0 120n 0.9 129.5n 0.9 130n 0 139.5n 0]
Vth234 (th234 0) vsource type=pwl wave=[0 0 9.5n 0 10n 0 19.5n 0 20n 0 29.5n 0 30n 0 39.5n 0 40n 0 49.5n 0 50n 0 59.5n 0 60n 0 69.5n 0 70n 0 79.5n 0 80n 0 89.5n 0 90n 0 99.5n 0 100n 0 109.5n 0 110n 0 119.5n 0 120n 0.9 129.5n 0.9 130n 0 139.5n 0]
Vth235 (th235 0) vsource type=pwl wave=[0 0 9.5n 0 10n 0 19.5n 0 20n 0 29.5n 0 30n 0 39.5n 0 40n 0 49.5n 0 50n 0 59.5n 0 60n 0 69.5n 0 70n 0 79.5n 0 80n 0 89.5n 0 90n 0 99.5n 0 100n 0 109.5n 0 110n 0 119.5n 0 120n 0.9 129.5n 0.9 130n 0 139.5n 0]
Vth236 (th236 0) vsource type=pwl wave=[0 0 9.5n 0 10n 0 19.5n 0 20n 0 29.5n 0 30n 0 39.5n 0 40n 0 49.5n 0 50n 0 59.5n 0 60n 0 69.5n 0 70n 0 79.5n 0 80n 0 89.5n 0 90n 0 99.5n 0 100n 0 109.5n 0 110n 0 119.5n 0 120n 0.9 129.5n 0.9 130n 0 139.5n 0]
Vth237 (th237 0) vsource type=pwl wave=[0 0 9.5n 0 10n 0 19.5n 0 20n 0 29.5n 0 30n 0 39.5n 0 40n 0 49.5n 0 50n 0 59.5n 0 60n 0 69.5n 0 70n 0 79.5n 0 80n 0 89.5n 0 90n 0 99.5n 0 100n 0 109.5n 0 110n 0 119.5n 0 120n 0.9 129.5n 0.9 130n 0 139.5n 0]
Vth238 (th238 0) vsource type=pwl wave=[0 0 9.5n 0 10n 0 19.5n 0 20n 0 29.5n 0 30n 0 39.5n 0 40n 0 49.5n 0 50n 0 59.5n 0 60n 0 69.5n 0 70n 0 79.5n 0 80n 0 89.5n 0 90n 0 99.5n 0 100n 0 109.5n 0 110n 0 119.5n 0 120n 0.9 129.5n 0.9 130n 0 139.5n 0]
Vth239 (th239 0) vsource type=pwl wave=[0 0 9.5n 0 10n 0 19.5n 0 20n 0 29.5n 0 30n 0 39.5n 0 40n 0 49.5n 0 50n 0 59.5n 0 60n 0 69.5n 0 70n 0 79.5n 0 80n 0 89.5n 0 90n 0 99.5n 0 100n 0 109.5n 0 110n 0 119.5n 0 120n 0.9 129.5n 0.9 130n 0 139.5n 0]
Vth240 (th240 0) vsource type=pwl wave=[0 0 9.5n 0 10n 0 19.5n 0 20n 0 29.5n 0 30n 0 39.5n 0 40n 0 49.5n 0 50n 0 59.5n 0 60n 0 69.5n 0 70n 0 79.5n 0 80n 0 89.5n 0 90n 0 99.5n 0 100n 0 109.5n 0 110n 0 119.5n 0 120n 0.9 129.5n 0.9 130n 0 139.5n 0]
Vth241 (th241 0) vsource type=pwl wave=[0 0 9.5n 0 10n 0 19.5n 0 20n 0 29.5n 0 30n 0 39.5n 0 40n 0 49.5n 0 50n 0 59.5n 0 60n 0 69.5n 0 70n 0 79.5n 0 80n 0 89.5n 0 90n 0 99.5n 0 100n 0 109.5n 0 110n 0 119.5n 0 120n 0.9 129.5n 0.9 130n 0 139.5n 0]
Vth242 (th242 0) vsource type=pwl wave=[0 0 9.5n 0 10n 0 19.5n 0 20n 0 29.5n 0 30n 0 39.5n 0 40n 0 49.5n 0 50n 0 59.5n 0 60n 0 69.5n 0 70n 0 79.5n 0 80n 0 89.5n 0 90n 0 99.5n 0 100n 0 109.5n 0 110n 0 119.5n 0 120n 0.9 129.5n 0.9 130n 0 139.5n 0]
Vth243 (th243 0) vsource type=pwl wave=[0 0 9.5n 0 10n 0 19.5n 0 20n 0 29.5n 0 30n 0 39.5n 0 40n 0 49.5n 0 50n 0 59.5n 0 60n 0 69.5n 0 70n 0 79.5n 0 80n 0 89.5n 0 90n 0 99.5n 0 100n 0 109.5n 0 110n 0 119.5n 0 120n 0.9 129.5n 0.9 130n 0 139.5n 0]
Vth244 (th244 0) vsource type=pwl wave=[0 0 9.5n 0 10n 0 19.5n 0 20n 0 29.5n 0 30n 0 39.5n 0 40n 0 49.5n 0 50n 0 59.5n 0 60n 0 69.5n 0 70n 0 79.5n 0 80n 0 89.5n 0 90n 0 99.5n 0 100n 0 109.5n 0 110n 0 119.5n 0 120n 0.9 129.5n 0.9 130n 0 139.5n 0]
Vth245 (th245 0) vsource type=pwl wave=[0 0 9.5n 0 10n 0 19.5n 0 20n 0 29.5n 0 30n 0 39.5n 0 40n 0 49.5n 0 50n 0 59.5n 0 60n 0 69.5n 0 70n 0 79.5n 0 80n 0 89.5n 0 90n 0 99.5n 0 100n 0 109.5n 0 110n 0 119.5n 0 120n 0.9 129.5n 0.9 130n 0 139.5n 0]
Vth246 (th246 0) vsource type=pwl wave=[0 0 9.5n 0 10n 0 19.5n 0 20n 0 29.5n 0 30n 0 39.5n 0 40n 0 49.5n 0 50n 0 59.5n 0 60n 0 69.5n 0 70n 0 79.5n 0 80n 0 89.5n 0 90n 0 99.5n 0 100n 0 109.5n 0 110n 0 119.5n 0 120n 0.9 129.5n 0.9 130n 0 139.5n 0]
Vth247 (th247 0) vsource type=pwl wave=[0 0 9.5n 0 10n 0 19.5n 0 20n 0 29.5n 0 30n 0 39.5n 0 40n 0 49.5n 0 50n 0 59.5n 0 60n 0 69.5n 0 70n 0 79.5n 0 80n 0 89.5n 0 90n 0 99.5n 0 100n 0 109.5n 0 110n 0 119.5n 0 120n 0.9 129.5n 0.9 130n 0 139.5n 0]
Vth248 (th248 0) vsource type=pwl wave=[0 0 9.5n 0 10n 0 19.5n 0 20n 0 29.5n 0 30n 0 39.5n 0 40n 0 49.5n 0 50n 0 59.5n 0 60n 0 69.5n 0 70n 0 79.5n 0 80n 0 89.5n 0 90n 0 99.5n 0 100n 0 109.5n 0 110n 0 119.5n 0 120n 0.9 129.5n 0.9 130n 0 139.5n 0]
Vth249 (th249 0) vsource type=pwl wave=[0 0 9.5n 0 10n 0 19.5n 0 20n 0 29.5n 0 30n 0 39.5n 0 40n 0 49.5n 0 50n 0 59.5n 0 60n 0 69.5n 0 70n 0 79.5n 0 80n 0 89.5n 0 90n 0 99.5n 0 100n 0 109.5n 0 110n 0 119.5n 0 120n 0.9 129.5n 0.9 130n 0 139.5n 0]
Vth250 (th250 0) vsource type=pwl wave=[0 0 9.5n 0 10n 0 19.5n 0 20n 0 29.5n 0 30n 0 39.5n 0 40n 0 49.5n 0 50n 0 59.5n 0 60n 0 69.5n 0 70n 0 79.5n 0 80n 0 89.5n 0 90n 0 99.5n 0 100n 0 109.5n 0 110n 0 119.5n 0 120n 0.9 129.5n 0.9 130n 0 139.5n 0]
Vth251 (th251 0) vsource type=pwl wave=[0 0 9.5n 0 10n 0 19.5n 0 20n 0 29.5n 0 30n 0 39.5n 0 40n 0 49.5n 0 50n 0 59.5n 0 60n 0 69.5n 0 70n 0 79.5n 0 80n 0 89.5n 0 90n 0 99.5n 0 100n 0 109.5n 0 110n 0 119.5n 0 120n 0.9 129.5n 0.9 130n 0 139.5n 0]
Vth252 (th252 0) vsource type=pwl wave=[0 0 9.5n 0 10n 0 19.5n 0 20n 0 29.5n 0 30n 0 39.5n 0 40n 0 49.5n 0 50n 0 59.5n 0 60n 0 69.5n 0 70n 0 79.5n 0 80n 0 89.5n 0 90n 0 99.5n 0 100n 0 109.5n 0 110n 0 119.5n 0 120n 0.9 129.5n 0.9 130n 0 139.5n 0]
Vth253 (th253 0) vsource type=pwl wave=[0 0 9.5n 0 10n 0 19.5n 0 20n 0 29.5n 0 30n 0 39.5n 0 40n 0 49.5n 0 50n 0 59.5n 0 60n 0 69.5n 0 70n 0 79.5n 0 80n 0 89.5n 0 90n 0 99.5n 0 100n 0 109.5n 0 110n 0 119.5n 0 120n 0.9 129.5n 0.9 130n 0 139.5n 0]
Vth254 (th254 0) vsource type=pwl wave=[0 0 9.5n 0 10n 0 19.5n 0 20n 0 29.5n 0 30n 0 39.5n 0 40n 0 49.5n 0 50n 0 59.5n 0 60n 0 69.5n 0 70n 0 79.5n 0 80n 0 89.5n 0 90n 0 99.5n 0 100n 0 109.5n 0 110n 0 119.5n 0 120n 0.9 129.5n 0.9 130n 0 139.5n 0]
Vth255 (th255 0) vsource type=pwl wave=[0 0 9.5n 0 10n 0 19.5n 0 20n 0 29.5n 0 30n 0 39.5n 0 40n 0 49.5n 0 50n 0 59.5n 0 60n 0 69.5n 0 70n 0 79.5n 0 80n 0 89.5n 0 90n 0 99.5n 0 100n 0 109.5n 0 110n 0 119.5n 0 120n 0 129.5n 0 130n 0 139.5n 0]

XDUT (th255 th254 th253 th252 th251 th250 th249 th248 th247 th246 th245 th244 th243 th242 th241 th240 th239 th238 th237 th236 th235 th234 th233 th232 th231 th230 th229 th228 th227 th226 th225 th224 th223 th222 th221 th220 th219 th218 th217 th216 th215 th214 th213 th212 th211 th210 th209 th208 th207 th206 th205 th204 th203 th202 th201 th200 th199 th198 th197 th196 th195 th194 th193 th192 th191 th190 th189 th188 th187 th186 th185 th184 th183 th182 th181 th180 th179 th178 th177 th176 th175 th174 th173 th172 th171 th170 th169 th168 th167 th166 th165 th164 th163 th162 th161 th160 th159 th158 th157 th156 th155 th154 th153 th152 th151 th150 th149 th148 th147 th146 th145 th144 th143 th142 th141 th140 th139 th138 th137 th136 th135 th134 th133 th132 th131 th130 th129 th128 th127 th126 th125 th124 th123 th122 th121 th120 th119 th118 th117 th116 th115 th114 th113 th112 th111 th110 th109 th108 th107 th106 th105 th104 th103 th102 th101 th100 th99 th98 th97 th96 th95 th94 th93 th92 th91 th90 th89 th88 th87 th86 th85 th84 th83 th82 th81 th80 th79 th78 th77 th76 th75 th74 th73 th72 th71 th70 th69 th68 th67 th66 th65 th64 th63 th62 th61 th60 th59 th58 th57 th56 th55 th54 th53 th52 th51 th50 th49 th48 th47 th46 th45 th44 th43 th42 th41 th40 th39 th38 th37 th36 th35 th34 th33 th32 th31 th30 th29 th28 th27 th26 th25 th24 th23 th22 th21 th20 th19 th18 th17 th16 th15 th14 th13 th12 th11 th10 th9 th8 th7 th6 th5 th4 th3 th2 th1 th0 b7 b6 b5 b4 b3 b2 b1 b0 valid) therm_to_bin_8b

simulatorOptions options evas_profile=balanced

tran tran stop=145n maxstep=100p
save valid th0 th1 th2 th3 th4 th5 th6 th7 th8 th9 th10 th11 th12 th13 th14 th15 th16 th17 th18 th19 th20 th21 th22 th23 th24 th25 th26 th27 th28 th29 th30 th31 th32 th33 th34 th35 th36 th37 th38 th39 th40 th41 th42 th43 th44 th45 th46 th47 th48 th49 th50 th51 th52 th53 th54 th55 th56 th57 th58 th59 th60 th61 th62 th63 th64 th65 th66 th67 th68 th69 th70 th71 th72 th73 th74 th75 th76 th77 th78 th79 th80 th81 th82 th83 th84 th85 th86 th87 th88 th89 th90 th91 th92 th93 th94 th95 th96 th97 th98 th99 th100 th101 th102 th103 th104 th105 th106 th107 th108 th109 th110 th111 th112 th113 th114 th115 th116 th117 th118 th119 th120 th121 th122 th123 th124 th125 th126 th127 th128 th129 th130 th131 th132 th133 th134 th135 th136 th137 th138 th139 th140 th141 th142 th143 th144 th145 th146 th147 th148 th149 th150 th151 th152 th153 th154 th155 th156 th157 th158 th159 th160 th161 th162 th163 th164 th165 th166 th167 th168 th169 th170 th171 th172 th173 th174 th175 th176 th177 th178 th179 th180 th181 th182
save th183 th184 th185 th186 th187 th188 th189 th190 th191 th192 th193 th194 th195 th196 th197 th198 th199 th200 th201 th202 th203 th204 th205 th206 th207 th208 th209 th210 th211 th212 th213 th214 th215 th216 th217 th218 th219 th220 th221 th222 th223 th224 th225 th226 th227 th228 th229 th230 th231 th232 th233 th234 th235 th236 th237 th238 th239 th240 th241 th242 th243 th244 th245 th246 th247 th248 th249 th250 th251 th252 th253 th254 th255 b0 b1 b2 b3 b4 b5 b6 b7
