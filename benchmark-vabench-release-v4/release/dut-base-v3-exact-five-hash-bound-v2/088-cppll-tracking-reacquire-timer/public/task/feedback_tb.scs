simulator lang=spectre
global 0

ahdl_include "./dut/cppll_timer_ref.va"
ahdl_include "./dut/ref_step_clk.va"

// Gold smoke testbench for CPPLL relock after a reference-frequency step.

vdd_SRC (vdd 0) vsource type=dc dc=0.9
vss_SRC (vss 0) vsource type=dc dc=0

XREF (vdd vss ref_clk) ref_step_clk \
    period_pre=20.4n period_post=19.8n t_switch=2u tedge=100p

XDUT (vdd vss ref_clk fb_clk dco_clk vctrl_mon lock) cppll_timer_ref \
    div_ratio=8 f_center=784.313725e6 kvco_hz_per_v=220e6 f_min=500e6 f_max=1.2e9 \
    kp=2.5e6 ki=8.0e4 vctrl_init=0.45 tedge=1n lock_tol=1.2n lock_count_target=4

simulatorOptions options evas_profile=balanced

tran tran stop=6u maxstep=5n errpreset=conservative
save vdd vss ref_clk fb_clk dco_clk vctrl_mon lock
