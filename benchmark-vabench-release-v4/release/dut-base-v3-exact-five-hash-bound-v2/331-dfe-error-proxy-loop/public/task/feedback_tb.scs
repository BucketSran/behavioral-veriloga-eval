simulator lang=spectre
global 0

ahdl_include "./dut/dfe_error_proxy_loop_top.va"
ahdl_include "./dut/decision_history.va"
ahdl_include "./dut/feedback_correction_core.va"

Vsample_in (sample_in 0) vsource type=pwl wave=[0 0.240 9n 0.240 15n 0.740 28n 0.740 34n 0.440 48n 0.440 80n 0.300]
Vdecision_clk (decision_clk 0) vsource type=pulse val0=0 val1=0.9 period=6n width=3n delay=1n rise=60p fall=60p
Vrst (rst 0) vsource type=pwl wave=[0 0.9 2.1n 0.9 2.2n 0 80n 0]
Venable (enable 0) vsource type=pwl wave=[0 0 5n 0 5.1n 0.9 56n 0.9 56.1n 0 62n 0 62.1n 0.9 80n 0.9]

XDUT (sample_in decision_clk rst enable tap_1 tap_0 corrected_out error_metric converged) dfe_error_proxy_loop_top

simulatorOptions options evas_profile=balanced

tran tran stop=80n maxstep=120p
save sample_in decision_clk rst enable tap_1 tap_0 corrected_out error_metric converged
