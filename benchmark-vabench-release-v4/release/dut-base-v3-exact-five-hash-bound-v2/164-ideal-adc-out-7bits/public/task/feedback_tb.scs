simulator lang=spectre
global 0

ahdl_include "./dut/ideal_adc_out_7bits_scalar.va"

Vdin0 (din0 0) vsource type=pwl wave=[0 0 7.95n 0 8n 0.9 17.95n 0.9 18n 0 27.95n 0 28n 0.9]
Vdin1 (din1 0) vsource type=pwl wave=[0 0 17.95n 0 18n 0.9]
Vdin2 (din2 0) vsource type=pwl wave=[0 0 7.95n 0 8n 0.9 17.95n 0.9 18n 0 27.95n 0 28n 0.9]
Vdin3 (din3 0) vsource type=pwl wave=[0 0 17.95n 0 18n 0.9]
Vdin4 (din4 0) vsource type=pwl wave=[0 0 7.95n 0 8n 0.9 17.95n 0.9 18n 0 27.95n 0 28n 0.9]
Vdin5 (din5 0) vsource type=pwl wave=[0 0 17.95n 0 18n 0.9]
Vdin6 (din6 0) vsource type=pwl wave=[0 0 7.95n 0 8n 0.9 17.95n 0.9 18n 0 27.95n 0 28n 0.9]

XDUT (din0 din1 din2 din3 din4 din5 din6 dout) ideal_adc_out_7bits_scalar

simulatorOptions options evas_profile=balanced

tran tran stop=26n maxstep=20p
save din0 din1 din2 din3 din4 din5 din6 dout
