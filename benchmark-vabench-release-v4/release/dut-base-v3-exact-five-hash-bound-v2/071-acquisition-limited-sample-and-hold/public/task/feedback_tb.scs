simulator lang=spectre
global 0

ahdl_include "./dut/acquisition_limited_sample_hold.va"

Vsample (sample 0) vsource type=pulse val0=0 val1=0.9 period=20n width=5n delay=5n rise=100p fall=100p
Vrst (rst 0) vsource type=pwl wave=[0 0.9 2n 0.9 2.1n 0 90n 0]
Vvin (vin 0) vsource type=pwl wave=[0 0.25 7n 0.25 14n 0.80 28n 0.80 34n 0.20 49n 0.20 54n 0.70 70n 0.70 75n 0.35 90n 0.35]

XDUT (sample rst vin vout metric) acquisition_limited_sample_hold

simulatorOptions options evas_profile=balanced

tran tran stop=70n maxstep=250p
save sample rst vin vout metric
