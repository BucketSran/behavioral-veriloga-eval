simulator lang=spectre
global 0

ahdl_include "./dut/supply_bias_validity_gate.va"

Vvdd (vdd 0) vsource type=pwl wave=[0 0.9 2n 0.9 2.05n 0.68 4n 0.68 4.05n 0.9 8n 0.9 8.05n 1.12 10n 1.12 10.05n 0.9]
Vvss (vss 0) vsource type=pwl wave=[0 0 10.5n 0 10.55n 0.12 11.5n 0.12 11.55n 0.06 13.5n 0.06 13.55n 0]
Vbias (vbias 0) vsource type=pwl wave=[0 0.45 6n 0.45 6.05n 0.15 8n 0.15 8.05n 0.45 11.5n 0.45 11.55n 0.78 13.5n 0.78 13.55n 0.45]
Ven (en 0) vsource type=pwl wave=[0 0.9]
Vpd (pd 0) vsource type=pwl wave=[0 0 14n 0 14.05n 0.9]

XDUT (vdd vss vbias en pd ok gated) supply_bias_validity_gate

simulatorOptions options evas_profile=balanced

tran tran stop=16n maxstep=10p
save en gated ok pd vbias vdd vss
