simulator lang=spectre
global 0

ahdl_include "./dut/iq_downconversion_chain.va"

Vclk (clk 0) vsource type=pulse val0=0 val1=0.9 period=2n width=1n rise=50p fall=50p
Vrst (rst 0) vsource type=pwl wave=[0 0.9 2n 0.9 2.1n 0 80n 0]
Vvin (vin 0) vsource type=pwl wave=[0 0.45 7.9n 0.45 8n 0.70 55.9n 0.70 56n 0.45 66n 0.45]

XDUT (clk rst vin out metric lo_i lo_q mix_i mix_q phase_mon) iq_downconversion_chain

simulatorOptions options evas_profile=balanced

tran tran stop=66n maxstep=0.5n
save clk rst vin out metric lo_i lo_q mix_i mix_q phase_mon
