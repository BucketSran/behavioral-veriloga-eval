simulator lang=spectre
global 0

ahdl_include "./dut/charge_pump_abstraction.va"

V_fb_clk (clk 0) vsource type=pulse val0=0 val1=0.9 period=1.6n width=0.7n rise=40p fall=40p
V_fb_rst (rst 0) vsource type=pwl wave=[0 0.9 2.4n 0.9 2.5n 0 62n 0 62.1n 0.9 65n 0.9 65.1n 0 70n 0]
V_fb_up (up 0) vsource type=pwl wave=[0 0 5n 0 5.1n 0.9 19n 0.9 19.1n 0 49n 0 49.1n 0.9 54n 0.9 54.1n 0 70n 0]
V_fb_dn (dn 0) vsource type=pwl wave=[0 0 29n 0 29.1n 0.9 44n 0.9 44.1n 0 49n 0 49.1n 0.9 54n 0.9 54.1n 0 70n 0]

XFB_DUT (clk rst up dn vctrl metric) charge_pump_abstraction

simulatorOptions options evas_profile=balanced

tran tran stop=70n maxstep=0.35n
save clk rst up dn vctrl metric
