simulator lang=spectre
global 0

ahdl_include "./dut/decision_router_logic.va"

Vvin1 (vin1 0) vsource type=pwl wave=[0 0 0.8n 0 0.85n 0 1.6n 0 1.65n 0 2.4n 0 2.45n 0.9 3.2n 0.9 3.25n 0.9 4.0n 0.9]
Vvin2 (vin2 0) vsource type=pwl wave=[0 0 0.8n 0 0.85n 0 1.6n 0 1.65n 0.9 2.4n 0.9 2.45n 0.9 3.2n 0.9 3.25n 0 4.0n 0]
Vvalid (valid 0) vsource type=pwl wave=[0 0 0.8n 0 0.85n 0.9 1.6n 0.9 1.65n 0.9 2.4n 0.9 2.45n 0.9 3.2n 0.9 3.25n 0.9 4.0n 0.9]
XDUT (vin1 vin2 valid x y z dm dl) decision_router_logic

simulatorOptions options evas_profile=balanced

tran tran stop=3.8n maxstep=5p
save vin1 vin2 valid x y z dm dl
