simulator lang=spectre
global 0

ahdl_include "./dut/hard_voltage_clamp_behavior.va"

Vin (vin 0) vsource type=pwl wave=[0 -0.5 10n -0.5 10.1n 0.3 20n 0.3 20.1n 0.9 30n 0.9 30.1n 0.1 45n 0.1]

XDUT (vin vout 0) hard_voltage_clamp_behavior vclamp_upper=0.6 vclamp_lower=-0.2

simulatorOptions options evas_profile=balanced

tran tran stop=40n maxstep=25p
save vin vout
