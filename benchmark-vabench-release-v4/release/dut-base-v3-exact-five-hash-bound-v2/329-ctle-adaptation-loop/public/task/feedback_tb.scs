simulator lang=spectre
global 0

ahdl_include "./dut/ctle_adaptation_loop_top.va"
ahdl_include "./dut/ctle_boost_core.va"
ahdl_include "./dut/boost_adapt_controller.va"

Vvin (vin 0) vsource type=pwl wave=[0 0.270 9n 0.270 15n 0.720 28n 0.720 34n 0.420 48n 0.420 80n 0.307]
Vclk (clk 0) vsource type=pulse val0=0 val1=0.9 period=6n width=3n delay=1n rise=60p fall=60p
Vrst (rst 0) vsource type=pwl wave=[0 0.9 2.1n 0.9 2.2n 0 80n 0]
Venable (enable 0) vsource type=pwl wave=[0 0 5n 0 5.1n 0.9 56n 0.9 56.1n 0 62n 0 62.1n 0.9 80n 0.9]
Vedge_metric_in (edge_metric_in 0) vsource type=pwl wave=[0 0.210 9n 0.210 15n 0.740 28n 0.740 34n 0.420 48n 0.420 80n 0.292]

XDUT (vin edge_metric_in clk rst enable boost_2 boost_1 boost_0 vout adapt_metric locked) ctle_adaptation_loop_top

simulatorOptions options evas_profile=balanced

tran tran stop=80n maxstep=120p
save vin edge_metric_in clk rst enable boost_2 boost_1 boost_0 vout adapt_metric locked
