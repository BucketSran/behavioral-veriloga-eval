simulator lang=spectre
global 0

ahdl_include "./dut/precision_rectifier_envelope_detector.va"

Vclk (clk 0) vsource type=pulse val0=0 val1=0.9 period=2n width=1n delay=0.5n rise=100p fall=100p
Vrst (rst 0) vsource type=pwl wave=[0 0.9 2n 0.9 2.1n 0 90n 0]
Vvin (vin 0) vsource type=pwl wave=[0 0.45 8n 0.75 16n 0.45 24n 0.15 32n 0.45 42n 0.85 54n 0.45 66n 0.35 78n 0.45 90n 0.45]

XDUT (clk rst vin rect env metric) precision_rectifier_envelope_detector

simulatorOptions options evas_profile=balanced

tran tran stop=90n maxstep=250p
save clk rst vin rect env metric
