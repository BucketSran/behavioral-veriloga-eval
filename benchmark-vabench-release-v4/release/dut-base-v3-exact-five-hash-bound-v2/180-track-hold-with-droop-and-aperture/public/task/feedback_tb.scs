simulator lang=spectre
global 0

ahdl_include "./dut/track_hold_aperture.va"

Vvin (vin 0) vsource type=pwl wave=[0 0.12 4n 0.12 10n 0.74 18n 0.22 26n 0.82 34n 0.18 48n 0.70 64n 0.35 80n 0.62]
Vtrack (track 0) vsource type=pwl wave=[0 0 2n 0 2.1n 0.9 12n 0.9 12.1n 0 20n 0 20.1n 0.9 30n 0.9 30.1n 0 42n 0 42.1n 0.9 54n 0.9 54.1n 0 66n 0 66.1n 0.9 80n 0.9]
Vrst (rst 0) vsource type=pwl wave=[0 0.9 0.8n 0.9 0.9n 0 80n 0]
Ven (enable 0) vsource type=pwl wave=[0 0 1.5n 0 1.6n 0.9 68n 0.9 68.1n 0 72n 0 72.1n 0.9 80n 0.9]

XDUT (vin track rst enable vhold aperture_metric droop_metric valid) track_hold_aperture

simulatorOptions options evas_profile=balanced

tran tran stop=80n maxstep=80p
save vin track rst enable vhold aperture_metric droop_metric valid
