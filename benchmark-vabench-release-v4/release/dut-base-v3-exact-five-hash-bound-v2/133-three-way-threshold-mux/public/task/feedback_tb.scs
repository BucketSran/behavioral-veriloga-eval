simulator lang=spectre
global 0

ahdl_include "./dut/three_way_threshold_mux.va"

Vin1 (sigin1 0) vsource dc=0.1
Vin2 (sigin2 0) vsource dc=0.5
Vin3 (sigin3 0) vsource dc=0.9
Vcp (cntrlp 0) vsource type=pwl wave=[0 0.0 10n 0.0 10.1n 0.45 20n 0.45 20.1n 0.90 35n 0.90]
Vcm (cntrlm 0) vsource dc=0.45

XDUT (sigin1 sigin2 sigin3 cntrlp cntrlm sigout) three_way_threshold_mux sigth_high=0.2 sigth_low=-0.2

simulatorOptions options evas_profile=balanced

tran tran stop=30n maxstep=25p
save cntrlm cntrlp sigin1 sigin2 sigin3 sigout
