simulator lang=spectre
global 0

ahdl_include "./dut/agc_receiver_leveling_loop.va"

Vclk (clk 0) vsource type=pulse val0=0 val1=0.9 period=2n width=1n rise=50p fall=50p
Vrst (rst 0) vsource type=pwl wave=[0 0.9 1.6n 0.9 1.7n 0 60n 0]
Vvin (vin 0) vsource type=pwl wave=[0 0.45 7.5n 0.535 22n 0.535 22.1n 0.77 36n 0.77 36.1n 0.54 60n 0.54]

XDUT (clk rst vin out metric gain_mon rssi_mon) agc_receiver_leveling_loop

simulatorOptions options evas_profile=balanced

tran tran stop=60n maxstep=0.5n
save clk rst vin out metric gain_mon rssi_mon
