simulator lang=spectre
global 0

ahdl_include "./dut/uvlo_brownout_detector.va"

V_clk (clk 0) vsource type=pulse val0=0 val1=0.9 period=2n width=1n rise=50p fall=50p
V_rst (rst 0) vsource type=pwl wave=[0 0.9 2n 0.9 2.1n 0 80n 0]
V_vin (vin 0) vsource type=pwl wave=[0 0.50 9.9n 0.50 10n 0.70 27.9n 0.70 28n 0.58 42.9n 0.58 43n 0.52 54.9n 0.52 55n 0.62 66.9n 0.62 67n 0.68 80n 0.68]

XDUT (clk rst vin out metric) uvlo_brownout_detector

simulatorOptions options evas_profile=balanced

tran tran stop=80n maxstep=0.5n
save clk rst vin out metric
