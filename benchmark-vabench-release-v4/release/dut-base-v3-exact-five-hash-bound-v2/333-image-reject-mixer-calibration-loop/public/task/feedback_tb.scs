simulator lang=spectre
global 0

ahdl_include "./dut/image_reject_mixer_cal_loop_top.va"
ahdl_include "./dut/quadrature_mixer_proxy.va"
ahdl_include "./dut/image_cal_controller.va"

Vrf_in (rf_in 0) vsource type=pwl wave=[0 0.210 9n 0.210 15n 0.700 28n 0.700 34n 0.440 48n 0.440 80n 0.292]
Vlo_i (lo_i 0) vsource type=pwl wave=[0 0.300 9n 0.300 15n 0.680 28n 0.680 34n 0.460 48n 0.460 80n 0.315]
Vlo_q (lo_q 0) vsource type=pwl wave=[0 0.240 9n 0.240 15n 0.680 28n 0.680 34n 0.440 48n 0.440 80n 0.300]
Vclk (clk 0) vsource type=pulse val0=0 val1=0.9 period=6n width=3n delay=1n rise=60p fall=60p
Vrst (rst 0) vsource type=pwl wave=[0 0.9 2.1n 0.9 2.2n 0 80n 0]
Venable (enable 0) vsource type=pwl wave=[0 0 5n 0 5.1n 0.9 56n 0.9 56.1n 0 62n 0 62.1n 0.9 80n 0.9]

XDUT (rf_in lo_i lo_q clk rst enable i_out q_out image_metric calibrated) image_reject_mixer_cal_loop_top

simulatorOptions options evas_profile=balanced

tran tran stop=80n maxstep=120p
save rf_in lo_i lo_q clk rst enable i_out q_out image_metric calibrated
