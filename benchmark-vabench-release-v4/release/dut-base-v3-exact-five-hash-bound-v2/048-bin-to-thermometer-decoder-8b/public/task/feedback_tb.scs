simulator lang=spectre
global 0

ahdl_include "./dut/bin_to_therm_8b.va"

Vb0 (b0 0) vsource type=pwl wave=[0 0 9.5n 0 10n 0.9 19.5n 0.9 20n 0 29.5n 0 30n 0.9 39.5n 0.9 40n 0.9 49.5n 0.9 50n 0.9 59.5n 0.9 60n 0 69.5n 0 70n 0.9 79.5n 0.9 80n 0.9 89.5n 0.9 90n 0.9 99.5n 0.9 100n 0 109.5n 0 110n 0 119.5n 0 120n 0.9 129.5n 0.9 130n 0.9 139.5n 0.9 145n 0.9]
Vb1 (b1 0) vsource type=pwl wave=[0 0 9.5n 0 10n 0 19.5n 0 20n 0.9 29.5n 0.9 30n 0.9 39.5n 0.9 40n 0.9 49.5n 0.9 50n 0.9 59.5n 0.9 60n 0 69.5n 0 70n 0.9 79.5n 0.9 80n 0.9 89.5n 0.9 90n 0.9 99.5n 0.9 100n 0 109.5n 0 110n 0 119.5n 0 120n 0.9 129.5n 0.9 130n 0 139.5n 0 145n 0]
Vb2 (b2 0) vsource type=pwl wave=[0 0 9.5n 0 10n 0 19.5n 0 20n 0 29.5n 0 30n 0 39.5n 0 40n 0.9 49.5n 0.9 50n 0.9 59.5n 0.9 60n 0 69.5n 0 70n 0.9 79.5n 0.9 80n 0.9 89.5n 0.9 90n 0.9 99.5n 0.9 100n 0 109.5n 0 110n 0 119.5n 0 120n 0.9 129.5n 0.9 130n 0.9 139.5n 0.9 145n 0.9]
Vb3 (b3 0) vsource type=pwl wave=[0 0 9.5n 0 10n 0 19.5n 0 20n 0 29.5n 0 30n 0 39.5n 0 40n 0 49.5n 0 50n 0.9 59.5n 0.9 60n 0 69.5n 0 70n 0.9 79.5n 0.9 80n 0.9 89.5n 0.9 90n 0.9 99.5n 0.9 100n 0 109.5n 0 110n 0.9 119.5n 0.9 120n 0.9 129.5n 0.9 130n 0 139.5n 0 145n 0]
Vb4 (b4 0) vsource type=pwl wave=[0 0 9.5n 0 10n 0 19.5n 0 20n 0 29.5n 0 30n 0 39.5n 0 40n 0 49.5n 0 50n 0 59.5n 0 60n 0.9 69.5n 0.9 70n 0.9 79.5n 0.9 80n 0.9 89.5n 0.9 90n 0.9 99.5n 0.9 100n 0 109.5n 0 110n 0 119.5n 0 120n 0.9 129.5n 0.9 130n 0 139.5n 0 145n 0]
Vb5 (b5 0) vsource type=pwl wave=[0 0 9.5n 0 10n 0 19.5n 0 20n 0 29.5n 0 30n 0 39.5n 0 40n 0 49.5n 0 50n 0 59.5n 0 60n 0 69.5n 0 70n 0 79.5n 0 80n 0.9 89.5n 0.9 90n 0.9 99.5n 0.9 100n 0 109.5n 0 110n 0 119.5n 0 120n 0.9 129.5n 0.9 130n 0 139.5n 0 145n 0]
Vb6 (b6 0) vsource type=pwl wave=[0 0 9.5n 0 10n 0 19.5n 0 20n 0 29.5n 0 30n 0 39.5n 0 40n 0 49.5n 0 50n 0 59.5n 0 60n 0 69.5n 0 70n 0 79.5n 0 80n 0 89.5n 0 90n 0.9 99.5n 0.9 100n 0 109.5n 0 110n 0.9 119.5n 0.9 120n 0.9 129.5n 0.9 130n 0 139.5n 0 145n 0]
Vb7 (b7 0) vsource type=pwl wave=[0 0 9.5n 0 10n 0 19.5n 0 20n 0 29.5n 0 30n 0 39.5n 0 40n 0 49.5n 0 50n 0 59.5n 0 60n 0 69.5n 0 70n 0 79.5n 0 80n 0 89.5n 0 90n 0 99.5n 0 100n 0.9 109.5n 0.9 110n 0.9 119.5n 0.9 120n 0.9 129.5n 0.9 130n 0 139.5n 0 145n 0]
Ven (en 0) vsource type=pwl wave=[0 0.9 130n 0.9 130.5n 0 145n 0]

XDUT (en b7 b6 b5 b4 b3 b2 b1 b0 th255 th254 th253 th252 th251 th250 th249 th248 th247 th246 th245 th244 th243 th242 th241 th240 th239 th238 th237 th236 th235 th234 th233 th232 th231 th230 th229 th228 th227 th226 th225 th224 th223 th222 th221 th220 th219 th218 th217 th216 th215 th214 th213 th212 th211 th210 th209 th208 th207 th206 th205 th204 th203 th202 th201 th200 th199 th198 th197 th196 th195 th194 th193 th192 th191 th190 th189 th188 th187 th186 th185 th184 th183 th182 th181 th180 th179 th178 th177 th176 th175 th174 th173 th172 th171 th170 th169 th168 th167 th166 th165 th164 th163 th162 th161 th160 th159 th158 th157 th156 th155 th154 th153 th152 th151 th150 th149 th148 th147 th146 th145 th144 th143 th142 th141 th140 th139 th138 th137 th136 th135 th134 th133 th132 th131 th130 th129 th128 th127 th126 th125 th124 th123 th122 th121 th120 th119 th118 th117 th116 th115 th114 th113 th112 th111 th110 th109 th108 th107 th106 th105 th104 th103 th102 th101 th100 th99 th98 th97 th96 th95 th94 th93 th92 th91 th90 th89 th88 th87 th86 th85 th84 th83 th82 th81 th80 th79 th78 th77 th76 th75 th74 th73 th72 th71 th70 th69 th68 th67 th66 th65 th64 th63 th62 th61 th60 th59 th58 th57 th56 th55 th54 th53 th52 th51 th50 th49 th48 th47 th46 th45 th44 th43 th42 th41 th40 th39 th38 th37 th36 th35 th34 th33 th32 th31 th30 th29 th28 th27 th26 th25 th24 th23 th22 th21 th20 th19 th18 th17 th16 th15 th14 th13 th12 th11 th10 th9 th8 th7 th6 th5 th4 th3 th2 th1 th0) bin_to_therm_8b

simulatorOptions options evas_profile=balanced

tran tran stop=145n maxstep=100p
save en b0 b1 b2 b3 b4 b5 b6 b7 th0 th1 th2 th3 th4 th5 th6 th7 th8 th9 th10 th11 th12 th13 th14 th15 th16 th17 th18 th19 th20 th21 th22 th23 th24 th25 th26 th27 th28 th29 th30 th31 th32 th33 th34 th35 th36 th37 th38 th39 th40 th41 th42 th43 th44 th45 th46 th47 th48 th49 th50 th51 th52 th53 th54 th55 th56 th57 th58 th59 th60 th61 th62 th63 th64 th65 th66 th67 th68 th69 th70 th71 th72 th73 th74 th75 th76 th77 th78 th79 th80 th81 th82 th83 th84 th85 th86 th87 th88 th89 th90 th91 th92 th93 th94 th95 th96 th97 th98 th99 th100 th101 th102 th103 th104 th105 th106 th107 th108 th109 th110 th111 th112 th113 th114 th115 th116 th117 th118 th119 th120 th121 th122 th123 th124 th125 th126 th127 th128 th129 th130 th131 th132 th133 th134 th135 th136 th137 th138 th139 th140 th141 th142 th143 th144 th145 th146 th147 th148 th149 th150 th151 th152 th153 th154 th155 th156 th157 th158 th159 th160 th161 th162 th163 th164 th165 th166 th167 th168 th169 th170 th171 th172 th173 th174 th175 th176 th177 th178
save th179 th180 th181 th182 th183 th184 th185 th186 th187 th188 th189 th190 th191 th192 th193 th194 th195 th196 th197 th198 th199 th200 th201 th202 th203 th204 th205 th206 th207 th208 th209 th210 th211 th212 th213 th214 th215 th216 th217 th218 th219 th220 th221 th222 th223 th224 th225 th226 th227 th228 th229 th230 th231 th232 th233 th234 th235 th236 th237 th238 th239 th240 th241 th242 th243 th244 th245 th246 th247 th248 th249 th250 th251 th252 th253 th254 th255
