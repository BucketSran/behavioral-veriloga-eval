simulator lang=spectre
global 0

ahdl_include "./dut/loop_filter_abstraction.va"

V_fb_clk (clk 0) vsource type=pulse val0=0 val1=0.9 period=1.8n width=0.8n rise=40p fall=40p
V_fb_rst (rst 0) vsource type=pwl wave=[0 0.9 2.4n 0.9 2.5n 0 62.9n 0 63n 0.9 66n 0.9 66.1n 0 72n 0]
V_fb_error (vin 0) vsource type=pwl wave=[0 0.45 24.4n 0.47 24.5n 0.78 33.9n 0.78 34n 0.18 47.9n 0.18 48n 0.47 57.9n 0.47 58n 0.70 62.9n 0.70 63n 0.45 72n 0.45]

XFB_DUT (clk rst vin out metric) loop_filter_abstraction

simulatorOptions options evas_profile=balanced

tran tran stop=72n maxstep=0.3n
save clk rst vin out metric
