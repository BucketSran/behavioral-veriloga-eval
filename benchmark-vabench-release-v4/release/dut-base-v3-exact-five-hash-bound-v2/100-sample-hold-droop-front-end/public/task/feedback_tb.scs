simulator lang=spectre
global 0

ahdl_include "./dut/sample_hold_droop_ref.va"

Vvdd (vdd 0) vsource dc=0.9
Vvss (vss 0) vsource dc=0.0
Vclk (clk 0) vsource type=pulse val0=0 val1=0.9 delay=5n rise=50p fall=50p width=8n period=20n
Vvin (vin 0) vsource type=pwl wave=[ \
  0 0.18 \
  24.95n 0.18 \
  25.10n 0.72 \
  64.95n 0.72 \
  65.10n 0.32 \
  104.95n 0.32 \
  105.10n 0.78 \
  144.95n 0.78 \
  145.10n 0.40 \
  170n 0.40 \
]

XDUT (vdd vss clk vin vout valid coarse) sample_hold_droop_ref vth=0.45 tau=90n dt=0.5n taperture=200p valid_width=2n trf=40p

simulatorOptions options evas_profile=balanced

tran tran stop=170n maxstep=0.1n
save vdd vss clk vin vout valid coarse
