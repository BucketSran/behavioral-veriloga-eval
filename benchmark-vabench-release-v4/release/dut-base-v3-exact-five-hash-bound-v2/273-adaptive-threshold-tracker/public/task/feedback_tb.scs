simulator lang=spectre
global 0

ahdl_include "./dut/adaptive_threshold_tracker.va"

Vclk (clk 0) vsource type=pulse val0=0 val1=0.9 delay=220p period=1n width=420p rise=25p fall=25p
Vrst (rst 0) vsource type=pwl wave=[0 0.9 1n 0.9 1.05n 0 9n 0 9.05n 0.9 9.9n 0.9 9.95n 0 15n 0]
Vadapt (adapt 0) vsource type=pwl wave=[0 0 1.5n 0 1.55n 0.9 6n 0.9 6.05n 0 10.5n 0 10.55n 0.9 15n 0.9]
Vvin (vin 0) vsource type=pwl wave=[0 0.3 2n 0.3 2.05n 0.62 4n 0.62 4.05n 0.78 6n 0.78 6.05n 0.4 8n 0.4 8.05n 0.18 10.5n 0.18 10.55n 0.88 15n 0.88]

XDUT (clk rst vin adapt trip threshold_mon margin_metric) adaptive_threshold_tracker

simulatorOptions options evas_profile=balanced

tran tran stop=15n maxstep=10p
save clk rst vin adapt trip threshold_mon margin_metric time
