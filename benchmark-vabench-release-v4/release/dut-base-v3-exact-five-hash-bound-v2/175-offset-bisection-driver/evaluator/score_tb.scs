simulator lang=spectre
global 0

ahdl_include "./dut/offset_bisection_driver.va"

Vclk (clk 0) vsource type=pwl wave=[0 0 1n 0 1.05n 0.9 2n 0.9 2.05n 0 3.5n 0 3.55n 0.9 4.5n 0.9 4.55n 0 6n 0 6.05n 0.9 7n 0.9 7.05n 0 8.5n 0 8.55n 0.9 9.5n 0.9 9.55n 0 11n 0 11.05n 0.9 12n 0.9 12.05n 0 13.5n 0 13.55n 0.9 14.5n 0.9 14.55n 0]
Vvout (vout 0) vsource type=pwl wave=[0 0.1 5.95n 0.1 6n 0.8 10.95n 0.8 11n 0.1 13.45n 0.1 13.50n 0.8]
Vvcm (vcm 0) vsource type=pwl wave=[0 0.48 6n 0.48 6.05n 0.52 16n 0.52]

XDUT (clk vout vcm vinp vinn) offset_bisection_driver

tran tran stop=16n maxstep=20p
save clk vout vcm vinp vinn
