simulator lang=spectre
global 0

ahdl_include "./dut/windowed_event_rate_monitor.va"

Vclk (clk 0) vsource type=pulse val0=0 val1=0.9 delay=250p period=1n width=450p rise=25p fall=25p
Vrst (rst 0) vsource type=pwl wave=[0 0.9 1n 0.9 1.05n 0 10.4n 0 10.45n 0.9 11.3n 0.9 11.35n 0 15n 0]
Vgate (gate 0) vsource type=pwl wave=[0 0 1.4n 0 1.45n 0.9 7.3n 0.9 7.35n 0 9n 0 9.05n 0.9 15n 0.9]
Vevent (event_in 0) vsource type=pwl wave=[0 0 2n 0 2.05n 0.9 3n 0.9 3.05n 0 4n 0 4.05n 0.9 6n 0.9 6.05n 0 9.5n 0 9.55n 0.9 10.2n 0.9 10.25n 0 12.2n 0 12.25n 0.9 15n 0.9]

XDUT (clk rst event_in gate rate average) windowed_event_rate_monitor

simulatorOptions options evas_profile=balanced

tran tran stop=15n maxstep=10p
save clk rst event_in gate rate average time
