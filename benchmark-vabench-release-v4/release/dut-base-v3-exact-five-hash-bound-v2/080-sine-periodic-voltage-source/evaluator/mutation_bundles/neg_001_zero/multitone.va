`include "constants.vams"
`include "disciplines.vams"

module multitone(VSS, OUT);
    input VSS;
    output OUT;
    electrical VSS, OUT;

    parameter real f1 = 1.0e6;
    parameter real f2 = 2.0e6;
    parameter real f3 = 3.0e6;
    parameter real a1 = 0.2;
    parameter real a2 = 0.1;
    parameter real a3 = 0.05;

    analog begin
        V(OUT, VSS) <+ transition(0.0);
    end
endmodule
