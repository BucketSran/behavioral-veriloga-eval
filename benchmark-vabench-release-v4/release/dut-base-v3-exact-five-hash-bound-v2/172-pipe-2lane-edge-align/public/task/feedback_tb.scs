simulator lang=spectre
global 0

ahdl_include "./dut/pipe_2lane_edge_align.va"

Vclk_align (clk_align 0) vsource type=pwl wave=[0 0 1n 0 1.05n 0.9 1.50n 0.9 1.55n 0 11n 0 11.05n 0.9 11.50n 0.9 11.55n 0 21n 0 21.05n 0.9 21.50n 0.9 21.55n 0 31n 0 31.05n 0.9 31.50n 0.9 31.55n 0]
Vdin1 (din1 0) vsource type=pwl wave=[0 0.1 7.95n 0.1 8n 0.4 17.95n 0.4 18n 0.7 27.95n 0.7 28n 0.2]
Vdin2 (din2 0) vsource type=pwl wave=[0 0.8 7.95n 0.8 8n 0.3 17.95n 0.3 18n 0.5 27.95n 0.5 28n 0.9]

XDUT (din1 din2 clk_align dout) pipe_2lane_edge_align

simulatorOptions options evas_profile=balanced

tran tran stop=40n maxstep=20p
save din1 din2 clk_align dout
