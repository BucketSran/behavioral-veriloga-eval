simulator lang=spectre
global 0

ahdl_include "./dut/autozero_comparator_preamplifier_top.va"
ahdl_include "./dut/offset_store_cell.va"
ahdl_include "./dut/clocked_comparator_core.va"

Vvinp (vinp 0) vsource type=pwl wave=[0 0.56 8n 0.56 14n 0.49 24n 0.49 34n 0.42 36n 0.42 38n 0.47 48n 0.47 60n 0.62 80n 0.57]
Vvinn (vinn 0) vsource type=pwl wave=[0 0.44 8n 0.44 14n 0.45 24n 0.45 34n 0.53 36n 0.53 38n 0.50 48n 0.50 60n 0.50 80n 0.45]
Vclk (clk 0) vsource type=pulse val0=0 val1=0.9 period=6n width=2.2n delay=3n rise=60p fall=60p
Vrst (rst 0) vsource type=pwl wave=[0 0.9 2.1n 0.9 2.2n 0 50n 0 50.1n 0.9 53.5n 0.9 53.6n 0 80n 0]
Vaz_en (az_en 0) vsource type=pwl wave=[0 0 8n 0 8.1n 0.9 12n 0.9 12.1n 0 32n 0 32.1n 0.9 36n 0.9 36.1n 0 58n 0 58.1n 0.9 64n 0.9 64.1n 0 80n 0]
Veval_en (eval_en 0) vsource type=pwl wave=[0 0 14n 0 14.1n 0.9 24n 0.9 24.1n 0 38n 0 38.1n 0.9 50n 0.9 50.1n 0 66n 0 66.1n 0.9 74n 0.9 74.1n 0 80n 0]

XDUT (vinp vinn clk rst az_en eval_en decision offset_store ready) autozero_comparator_preamplifier_top

simulatorOptions options evas_profile=balanced

tran tran stop=80n maxstep=80p
save vinp vinn clk rst az_en eval_en decision offset_store ready
