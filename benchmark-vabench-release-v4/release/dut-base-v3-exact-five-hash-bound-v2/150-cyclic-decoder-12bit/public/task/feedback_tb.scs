simulator lang=spectre
global 0

ahdl_include "./dut/cyclic_decoder_12bit.va"

Vd0 (d0 0) vsource type=pwl wave=[0 0 9.9n 0 10.1n 0.9 19.9n 0.9 20.1n 0 29.9n 0 30.1n 0.9 40n 0.9]
Vd1 (d1 0) vsource type=pwl wave=[0 0 9.9n 0 10.1n 0 19.9n 0 20.1n 0.9 29.9n 0.9 30.1n 0.9 40n 0.9]
Vd2 (d2 0) vsource type=pwl wave=[0 0 9.9n 0 10.1n 0.9 19.9n 0.9 20.1n 0 29.9n 0 30.1n 0.9 40n 0.9]
Vd3 (d3 0) vsource type=pwl wave=[0 0 9.9n 0 10.1n 0 19.9n 0 20.1n 0.9 29.9n 0.9 30.1n 0.9 40n 0.9]
Vd4 (d4 0) vsource type=pwl wave=[0 0 9.9n 0 10.1n 0.9 19.9n 0.9 20.1n 0 29.9n 0 30.1n 0.9 40n 0.9]
Vd5 (d5 0) vsource type=pwl wave=[0 0 9.9n 0 10.1n 0 19.9n 0 20.1n 0.9 29.9n 0.9 30.1n 0.9 40n 0.9]
Vd6 (d6 0) vsource type=pwl wave=[0 0 9.9n 0 10.1n 0.9 19.9n 0.9 20.1n 0 29.9n 0 30.1n 0.9 40n 0.9]
Vd7 (d7 0) vsource type=pwl wave=[0 0 9.9n 0 10.1n 0 19.9n 0 20.1n 0.9 29.9n 0.9 30.1n 0.9 40n 0.9]
Vd8 (d8 0) vsource type=pwl wave=[0 0 9.9n 0 10.1n 0.9 19.9n 0.9 20.1n 0 29.9n 0 30.1n 0.9 40n 0.9]
Vd9 (d9 0) vsource type=pwl wave=[0 0 9.9n 0 10.1n 0 19.9n 0 20.1n 0.9 29.9n 0.9 30.1n 0.9 40n 0.9]
Vd10 (d10 0) vsource type=pwl wave=[0 0 9.9n 0 10.1n 0.9 19.9n 0.9 20.1n 0 29.9n 0 30.1n 0.9 40n 0.9]
Vd11 (d11 0) vsource type=pwl wave=[0 0 9.9n 0 10.1n 0 19.9n 0 20.1n 0.9 29.9n 0.9 30.1n 0.9 40n 0.9]
Vclk (clks 0) vsource type=pwl wave=[0 0 2n 0 2.1n 0.9 2.5n 0.9 2.6n 0 12n 0 12.1n 0.9 12.5n 0.9 12.6n 0 22n 0 22.1n 0.9 22.5n 0.9 22.6n 0 32n 0 32.1n 0.9 32.5n 0.9 32.6n 0 38n 0]

XDUT (d0 d1 d2 d3 d4 d5 d6 d7 d8 d9 d10 d11 clks dout) cyclic_decoder_12bit

simulatorOptions options evas_profile=balanced

tran tran stop=25n maxstep=20p
save clks d0 d1 d10 d11 d2 d3 d4 d5 d6 d7 d8 d9 dout
