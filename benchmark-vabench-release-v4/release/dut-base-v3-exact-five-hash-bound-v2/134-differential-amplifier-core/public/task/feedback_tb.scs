simulator lang=spectre
global 0

ahdl_include "./dut/differential_amplifier_core.va"

Vp (sigin_p 0) vsource type=pwl wave=[0 0.25 10n 0.25 10.1n 0.45 20n 0.45 20.1n 0.65 30n 0.65 30.1n 0.55 45n 0.55]
Vn (sigin_n 0) vsource dc=0.45

XDUT (sigin_p sigin_n sigout) differential_amplifier_core

simulatorOptions options evas_profile=balanced

tran tran stop=40n maxstep=25p
save sigin_n sigin_p sigout
