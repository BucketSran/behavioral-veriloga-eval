simulator lang=spectre
global 0

ahdl_include "./dut/attenuator_gain.va"

Vin (vin 0) vsource type=pwl wave=[0 0.2 10n 0.2 10.1n 0.8 20n 0.8 20.1n 0.4 40n 0.4]

XDUT (vin vout) attenuator_gain attenuation=6.020599913279624

simulatorOptions options evas_profile=balanced

tran tran stop=35n maxstep=25p
save vin vout
