simulator lang=spectre
global 0

ahdl_include "./dut/comparator_offset_search_ref.va"

Vvdd (vdd 0) vsource dc=0.9
Vvss (vss 0) vsource dc=0.0
Vinn (inn 0) vsource dc=0.5
Vinp (inp 0) vsource type=pwl wave=[ \
    0    0.490 \
    80n 0.520 \
    100n 0.520 \
]

XDUT (vdd vss inp inn outp trip_v offset_est valid) comparator_offset_search_ref

simulatorOptions options evas_profile=balanced

tran tran stop=100n maxstep=50p errpreset=conservative
save vdd vss inp inn outp trip_v offset_est valid
