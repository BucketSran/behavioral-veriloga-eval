simulator lang=spectre
global 0

ahdl_include "./dut/soft_hysteretic_limiter.va"

// Public feedback drives high/low limiting and two distinct dead-band holds.
V_clk (clk 0) vsource type=pulse val0=0 val1=0.9 period=2.5n delay=700p rise=40p fall=40p width=1.1n
V_rst (rst 0) vsource type=pwl wave=[0 0.9 3.4n 0.9 3.5n 0 74n 0]
V_vin (vin 0) vsource type=pwl wave=[0 0.45 10n 0.45 10.2n 0.88 28n 0.88 28.2n 0.49 39n 0.49 39.2n 0.12 58n 0.12 58.2n 0.41 69n 0.41 69.2n 0.76 74n 0.76]

XDUT (clk rst vin out metric) soft_hysteretic_limiter

simulatorOptions options evas_profile=balanced

tran tran stop=74n maxstep=125p
save clk rst vin out metric
