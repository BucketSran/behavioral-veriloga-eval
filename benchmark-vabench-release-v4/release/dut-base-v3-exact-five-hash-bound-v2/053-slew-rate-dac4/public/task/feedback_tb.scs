simulator lang=spectre
global 0

ahdl_include "./dut/slew_rate_dac4.va"

Vd3 (d3 0) vsource type=pwl wave=[0 0 2n 0 2.02n 0.9 14n 0.9 14.02n 0 24n 0 24.02n 0.9]
Vd2 (d2 0) vsource type=pwl wave=[0 0 2n 0 2.02n 0.9 14n 0.9 14.02n 0 24n 0 24.02n 0.9]
Vd1 (d1 0) vsource type=pwl wave=[0 0 2n 0 2.02n 0.9 14n 0.9 14.02n 0.9 24n 0.9 24.02n 0]
Vd0 (d0 0) vsource type=pwl wave=[0 0 2n 0 2.02n 0.9 14n 0.9 14.02n 0.9 24n 0.9 24.02n 0]

XDUT (d3 d2 d1 d0 vout) slew_rate_dac4

simulatorOptions options evas_profile=balanced

tran tran stop=34n maxstep=50p
save d3 d2 d1 d0 vout
