simulator lang=spectre
global 0

ahdl_include "./dut/iterative_isar_dac.va"

Vrst (rst 0) vsource type=pwl wave=[0 0 0.40n 0 0.45n 1.0 0.80n 1.0 0.85n 0 8.80n 0 8.85n 1.0 9.20n 1.0 9.25n 0]
Vclk (clk 0) vsource type=pwl wave=[0 0 1.2n 0 1.25n 1.0 1.55n 1.0 1.60n 0 2.6n 0 2.65n 1.0 2.95n 1.0 3.00n 0 4.0n 0 4.05n 1.0 4.35n 1.0 4.40n 0 5.4n 0 5.45n 1.0 5.75n 1.0 5.80n 0 6.8n 0 6.85n 1.0 7.15n 1.0 7.20n 0 10.0n 0 10.05n 1.0 10.35n 1.0 10.40n 0 11.4n 0 11.45n 1.0 11.75n 1.0 11.80n 0 12.8n 0 12.85n 1.0 13.15n 1.0 13.20n 0]
Vdcmp (dcmp 0) vsource type=pwl wave=[0 0 2.2n 0 2.25n 1.0 3.6n 1.0 3.65n 0 6.3n 0 6.35n 1.0 10.8n 1.0 10.85n 0 12.2n 0 12.25n 1.0]

XDUT (dcmp rst clk vdac) iterative_isar_dac range=0.2 lsb=0.00625 radix=2

tran tran stop=14n maxstep=20p
save dcmp rst clk vdac
