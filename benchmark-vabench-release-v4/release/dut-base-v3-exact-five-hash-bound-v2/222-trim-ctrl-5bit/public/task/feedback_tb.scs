simulator lang=spectre
global 0

ahdl_include "./dut/trim_ctrl_5bit.va"

Vain (ain 0) vsource type=pwl wave=[0 0 0.9n 0 0.95n 3 1.8n 3 1.85n 18 2.7n 18 2.75n 27 3.8n 27]
XDUT (ain dout0 dout1 dout2 dout3 dout4) trim_ctrl_5bit

simulatorOptions options evas_profile=balanced

tran tran stop=3.5n maxstep=5p
save ain dout0 dout1 dout2 dout3 dout4
