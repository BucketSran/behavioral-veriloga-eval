simulator lang=spectre
global 0

ahdl_include "./dut/successive_approximation_calibration_search_fsm.va"

// Public feedback alternates signed decisions, then changes vin after done to test hold.
V_clk (clk 0) vsource type=pulse val0=0 val1=0.9 period=3n delay=900p rise=50p fall=50p width=1.25n
V_rst (rst 0) vsource type=pwl wave=[0 0.9 4.2n 0.9 4.3n 0 30n 0]
V_vin (vin 0) vsource type=pwl wave=[0 0.45 5.8n 0.45 6n 0.72 8.8n 0.72 9n 0.21 11.8n 0.21 12n 0.69 14.8n 0.69 15n 0.24 18n 0.24 18.2n 0.82 30n 0.82]

XDUT (clk rst vin out metric) successive_approximation_calibration_search_fsm

simulatorOptions options evas_profile=balanced

tran tran stop=30n maxstep=100p
save clk rst vin out metric
