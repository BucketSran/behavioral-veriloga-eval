simulator lang=spectre
global 0

ahdl_include "./dut/differential_vco_clip_idtmod.va"

// Visible smoke testbench for differential_vco_clip_idtmod.
// V(vinp,vinm)=0.65-0.35=0.30 => freq=20e6+160e6*0.30=68 MHz.

Vinp (vinp 0) vsource dc=0.65 type=dc
Vinm (vinm 0) vsource dc=0.35 type=dc

XDUT (vinp vinm outp outm metric) differential_vco_clip_idtmod

simulatorOptions options evas_profile=balanced

tran tran stop=1.5u maxstep=5n
save vinp vinm outp outm metric
