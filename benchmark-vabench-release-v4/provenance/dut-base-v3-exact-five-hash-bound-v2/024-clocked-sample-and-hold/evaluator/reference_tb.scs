simulator lang=spectre
global 0

ahdl_include "./dut/sample_hold.va"

V_VDD (vdd 0) vsource dc=1.0
V_VSS (vss 0) vsource dc=0.1
V_IN (in vss) vsource type=pwl wave=[0 0 4.0n    0.78 24.0n   0.22 240n 0.22]
V_CLK (clk vss) vsource type=pulse val0=0 val1=0.9 period=20n delay=1n rise=200p fall=200p width=10n
XDUT (vdd vss in clk out) sample_hold

simulatorOptions options evas_profile=balanced

tran tran stop=1u maxstep=1n
save vdd vss in clk out
