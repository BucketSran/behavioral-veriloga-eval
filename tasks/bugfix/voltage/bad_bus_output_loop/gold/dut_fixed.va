`include "constants.vams"
`include "disciplines.vams"

// Fixed version: drive each output bit independently.
module bin4_out (VDD, VSS, CODE, DOUT);
    inout VDD, VSS;
    input [3:0] CODE;
    output [3:0] DOUT;
    electrical VDD, VSS;
    electrical [3:0] CODE, DOUT;

    parameter real vth = 0.45;
    parameter real td  = 0p;
    parameter real trf = 20p;

    integer i;
    analog begin
        for (i = 0; i < 4; i = i + 1)
            V(DOUT[i]) <+ transition((V(CODE[i]) > vth) ? V(VDD) : V(VSS), td, trf, trf);
    end
endmodule
