// therm2bin gold smoke testbench
// Phase A (0–30ns):  T0 only active      → code=1  → B0=1, B3=B2=B1=0
// Phase B (30–60ns): T0..T3 active       → code=4  → B2=1, others=0
// Phase C (60–100ns): T0..T14 all active → code=15 → B3=B2=B1=B0=1
// Check: B3=B2=B1=B0=1 in final window.
simulator lang=spectre
global 0

ahdl_include "therm2bin.va"

VT0  (T0  0) vsource type=pwl wave=[0 0  4.9n 0  5n 0.9  100n 0.9]
VT1  (T1  0) vsource type=pwl wave=[0 0  29.9n 0  30n 0.9  100n 0.9]
VT2  (T2  0) vsource type=pwl wave=[0 0  29.9n 0  30n 0.9  100n 0.9]
VT3  (T3  0) vsource type=pwl wave=[0 0  29.9n 0  30n 0.9  100n 0.9]
VT4  (T4  0) vsource type=pwl wave=[0 0  59.9n 0  60n 0.9  100n 0.9]
VT5  (T5  0) vsource type=pwl wave=[0 0  59.9n 0  60n 0.9  100n 0.9]
VT6  (T6  0) vsource type=pwl wave=[0 0  59.9n 0  60n 0.9  100n 0.9]
VT7  (T7  0) vsource type=pwl wave=[0 0  59.9n 0  60n 0.9  100n 0.9]
VT8  (T8  0) vsource type=pwl wave=[0 0  59.9n 0  60n 0.9  100n 0.9]
VT9  (T9  0) vsource type=pwl wave=[0 0  59.9n 0  60n 0.9  100n 0.9]
VT10 (T10 0) vsource type=pwl wave=[0 0  59.9n 0  60n 0.9  100n 0.9]
VT11 (T11 0) vsource type=pwl wave=[0 0  59.9n 0  60n 0.9  100n 0.9]
VT12 (T12 0) vsource type=pwl wave=[0 0  59.9n 0  60n 0.9  100n 0.9]
VT13 (T13 0) vsource type=pwl wave=[0 0  59.9n 0  60n 0.9  100n 0.9]
VT14 (T14 0) vsource type=pwl wave=[0 0  59.9n 0  60n 0.9  100n 0.9]

IDUT (T0 T1 T2 T3 T4 T5 T6 T7 T8 T9 T10 T11 T12 T13 T14 B3 B2 B1 B0) \
    therm2bin vth=0.45 vdd=0.9

tran tran stop=100n maxstep=2n
save B3:d B2:d B1:d B0:d
