`include "constants.vams"
`include "disciplines.vams"

// Reference programmable clock divider for spec-to-va task.
// - 8-bit ratio code (1..255)
// - synchronous active-low reset
// - lock goes high after first complete output period
module clk_divider_ref (
    input electrical clk_in,
    input electrical rst_n,
    input electrical div_code_0,
    input electrical div_code_1,
    input electrical div_code_2,
    input electrical div_code_3,
    input electrical div_code_4,
    input electrical div_code_5,
    input electrical div_code_6,
    input electrical div_code_7,
    output electrical clk_out,
    output electrical lock
);

parameter real vdd = 0.9;
parameter real vth = 0.45;
parameter real trf = 10p;
parameter real td  = 0p;

integer ratio;
integer prev_ratio;
integer count;
integer low_len;
integer high_len;
integer segment_len;
integer out_state;
integer lock_state;
integer out_rise_count;
integer in_rise_count;

analog begin
    @(initial_step) begin
        ratio = 1;
        prev_ratio = 1;
        count = 0;
        low_len = 1;
        high_len = 1;
        segment_len = 1;
        out_state = 0;
        lock_state = 0;
        out_rise_count = 0;
        in_rise_count = 0;
    end

    @(cross(V(clk_in) - vth, +1) or cross(V(clk_in) - vth, -1)) begin
        ratio = (V(div_code_0) > vth ? 1 : 0)
              + (V(div_code_1) > vth ? 2 : 0)
              + (V(div_code_2) > vth ? 4 : 0)
              + (V(div_code_3) > vth ? 8 : 0)
              + (V(div_code_4) > vth ? 16 : 0)
              + (V(div_code_5) > vth ? 32 : 0)
              + (V(div_code_6) > vth ? 64 : 0)
              + (V(div_code_7) > vth ? 128 : 0);

        if (ratio < 1)
            ratio = 1;

        if (V(rst_n) < vth) begin
            prev_ratio = ratio;
            count = 0;
            low_len = (ratio > 1) ? (ratio / 2) : 1;
            if (low_len < 1)
                low_len = 1;
            high_len = (ratio > 1) ? (ratio - low_len) : 1;
            segment_len = low_len;
            out_state = 0;
            lock_state = 0;
            out_rise_count = 0;
            in_rise_count = 0;
        end else if (ratio == 1) begin
            if (prev_ratio != 1) begin
                prev_ratio = 1;
                count = 0;
                out_state = 0;
                lock_state = 0;
                out_rise_count = 0;
                in_rise_count = 0;
            end
            if (V(clk_in) > vth) begin
                out_state = 1;
                in_rise_count = in_rise_count + 1;
                if (in_rise_count >= 2)
                    lock_state = 1;
            end else begin
                out_state = 0;
            end
        end else begin
            if (prev_ratio != ratio) begin
                prev_ratio = ratio;
                count = 0;
                low_len = ratio / 2;
                if (low_len < 1)
                    low_len = 1;
                high_len = ratio - low_len;
                segment_len = low_len;
                out_state = 0;
                lock_state = 0;
                out_rise_count = 0;
            end

            // Count only on input rising edges; alternate low/high segment lengths.
            if (V(clk_in) > vth) begin
                count = count + 1;
                if (count >= segment_len) begin
                    count = 0;
                    if (out_state == 0) begin
                        out_state = 1;
                        segment_len = high_len;
                        out_rise_count = out_rise_count + 1;
                        if (out_rise_count >= 2)
                            lock_state = 1;
                    end else begin
                        out_state = 0;
                        segment_len = low_len;
                    end
                end
            end
        end
    end

    V(clk_out) <+ transition(out_state ? vdd : 0.0, td, trf, trf);
    V(lock)    <+ transition(lock_state ? vdd : 0.0, td, trf, trf);
end

endmodule
