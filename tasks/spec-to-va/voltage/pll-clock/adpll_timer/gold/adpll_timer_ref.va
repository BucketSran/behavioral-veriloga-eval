`include "constants.vams"
`include "disciplines.vams"

module adpll_timer_ref (
    inout  electrical VDD,
    inout  electrical VSS,
    input  electrical ref_clk,
    output electrical fb_clk,
    output electrical dco_clk,
    output electrical vctrl_mon,
    output electrical lock
);
    parameter integer div_ratio = 8 from [1:inf);
    parameter real f_center = 760.0e6 from (0:inf);
    parameter real freq_step_hz = 5.0e6 from (0:inf);
    parameter real f_min = 500.0e6 from (0:inf);
    parameter real f_max = 1.2e9 from (0:inf);
    parameter integer code_min = 0 from [0:inf);
    parameter integer code_max = 63 from [1:inf);
    parameter integer code_center = 32 from [0:inf);
    parameter integer code_init = 38 from [0:inf);
    parameter real tedge = 1n from (0:inf);
    parameter real lock_tol = 1.5n from (0:inf);
    parameter integer lock_count_target = 6 from [1:inf);

    real vh;
    real vl;
    real vth;
    real t_ref_prev;
    real t_ref_last;
    real t_fb_last;
    real ref_period;
    real phase_err;
    real dco_freq;
    real dco_half_period;
    real t_next_toggle;
    real code_norm;

    integer ctrl_code;
    integer dco_state;
    integer fb_state;
    integer div_cnt;
    integer lock_state;
    integer lock_streak;

    analog begin
        vh = V(VDD);
        vl = V(VSS);
        vth = 0.5 * (vh + vl);

        @(initial_step) begin
            t_ref_prev = -1.0;
            t_ref_last = -1.0;
            t_fb_last = -1.0;
            ref_period = 20e-9;
            phase_err = 0.0;

            ctrl_code = code_init;
            if (ctrl_code < code_min) ctrl_code = code_min;
            if (ctrl_code > code_max) ctrl_code = code_max;

            dco_state = 0;
            fb_state = 0;
            div_cnt = 0;
            lock_state = 0;
            lock_streak = 0;

            dco_freq = f_center + freq_step_hz * (ctrl_code - code_center);
            if (dco_freq < f_min) dco_freq = f_min;
            if (dco_freq > f_max) dco_freq = f_max;
            dco_half_period = 0.5 / dco_freq;
            t_next_toggle = $abstime + dco_half_period;
        end

        @(cross(V(ref_clk) - vth, +1)) begin
            t_ref_prev = t_ref_last;
            t_ref_last = $abstime;

            if (t_fb_last >= 0.0) begin
                phase_err = t_ref_last - t_fb_last;

                if (t_ref_prev >= 0.0) begin
                    ref_period = t_ref_last - t_ref_prev;
                    if (ref_period > 1e-15) begin
                        while (phase_err > 0.5 * ref_period) phase_err = phase_err - ref_period;
                        while (phase_err < -0.5 * ref_period) phase_err = phase_err + ref_period;
                    end
                end

                if (phase_err > lock_tol) begin
                    ctrl_code = ctrl_code - 1;
                    lock_streak = 0;
                end else if (phase_err < -lock_tol) begin
                    ctrl_code = ctrl_code + 1;
                    lock_streak = 0;
                end else begin
                    lock_streak = lock_streak + 1;
                end

                if (ctrl_code < code_min) ctrl_code = code_min;
                if (ctrl_code > code_max) ctrl_code = code_max;
                lock_state = (lock_streak >= lock_count_target) ? 1 : 0;
            end
        end

        @(timer(t_next_toggle)) begin
            dco_state = 1 - dco_state;

            if (dco_state == 1) begin
                div_cnt = div_cnt + 1;
                if (div_cnt >= div_ratio) begin
                    div_cnt = 0;
                    fb_state = 1 - fb_state;
                end
            end

            dco_freq = f_center + freq_step_hz * (ctrl_code - code_center);
            if (dco_freq < f_min) dco_freq = f_min;
            if (dco_freq > f_max) dco_freq = f_max;

            $bound_step(1.0 / (64.0 * dco_freq));

            dco_half_period = 0.5 / dco_freq;
            t_next_toggle = t_next_toggle + dco_half_period;
        end

        @(cross(V(fb_clk) - vth, +1)) begin
            t_fb_last = $abstime;
        end

        code_norm = ctrl_code / code_max;
        if (code_norm < 0.0) code_norm = 0.0;
        if (code_norm > 1.0) code_norm = 1.0;

        V(dco_clk) <+ vl + (vh - vl) * transition(dco_state ? 1.0 : 0.0, 0.0, tedge, tedge);
        V(fb_clk) <+ vl + (vh - vl) * transition(fb_state ? 1.0 : 0.0, 0.0, tedge, tedge);
        V(vctrl_mon) <+ vl + (vh - vl) * code_norm;
        V(lock) <+ vl + (vh - vl) * transition(lock_state ? 1.0 : 0.0, 0.0, tedge, tedge);
    end

endmodule
