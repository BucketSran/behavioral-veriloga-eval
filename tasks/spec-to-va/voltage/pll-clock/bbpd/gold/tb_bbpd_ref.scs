simulator lang=spectre
global 0

ahdl_include "bbpd_ref.va"

Vclk          (clk 0)          vsource type=pulse val0=0 val1=0.9 period=1n delay=0.1n rise=20p fall=20p width=0.5n
Vretimed_data (retimed_data 0) vsource type=pulse val0=0 val1=0.9 period=1n delay=0.6n rise=20p fall=20p width=0.5n
Vdata         (data 0)         vsource type=pulse val0=0 val1=0.9 period=0.8n delay=0.25n rise=20p fall=20p width=0.4n

XDUT (data clk retimed_data up down) bbpd_ref

tran tran stop=60n maxstep=50p
save data:2e clk:2e retimed_data:2e up:2e down:2e
