// 10-bit SAR ADC logic block — EVAS-compatible gold
// CLKS drives the SAR bit-sequencer (1 bit decision per rising edge).
// After 10 CLKS cycles: DP_DAC[9:0] holds result, RDY asserts for 1 cycle.
// VDD/VSS are power ports (provide supply references for transitions).

`include "constants.vams"
`include "disciplines.vams"
`default_transition 50p

module sar_logic(
    inout  electrical VDD,
    inout  electrical VSS,
    input  electrical CLKS,
    input  electrical DCOMP,
    output electrical DP_DAC_9,
    output electrical DP_DAC_8,
    output electrical DP_DAC_7,
    output electrical DP_DAC_6,
    output electrical DP_DAC_5,
    output electrical DP_DAC_4,
    output electrical DP_DAC_3,
    output electrical DP_DAC_2,
    output electrical DP_DAC_1,
    output electrical DP_DAC_0,
    output electrical RDY
);

parameter real vth   = 0.45;
parameter real vdd   = 0.9;
parameter real tedge = 100p;

integer state;           // 0..9 = bit phase; 10 = RDY cycle
integer dac_reg[9:0];    // SAR register (MSB=9, LSB=0)
real    dac_lev[9:0];
real    rdy_level;
integer i;

analog begin
    @(initial_step) begin
        state     = 0;
        rdy_level = 0.0;
        for (i = 0; i <= 9; i = i + 1) begin
            dac_reg[i] = 0;
            dac_lev[i] = 0.0;
        end
        // MSB trial: set bit 9
        dac_reg[9] = 1;
        dac_lev[9] = vdd;
        $strobe("[sar_logic] INIT");
    end

    @(cross(V(CLKS) - vth, +1)) begin
        if (V(VDD) > vth) begin
            if (state < 10) begin
                // Record comparator result for current trial bit
                if (V(DCOMP) < vth)
                    dac_reg[9 - state] = 0;  // bit rejected
                dac_lev[9 - state] = dac_reg[9 - state] ? vdd : 0.0;

                state = state + 1;

                if (state < 10) begin
                    // Set next trial bit
                    dac_reg[9 - state] = 1;
                    dac_lev[9 - state] = vdd;
                end
                rdy_level = (state >= 10) ? vdd : 0.0;

            end else begin
                // RDY cycle done — start new conversion
                rdy_level = 0.0;
                state     = 0;
                for (i = 0; i <= 9; i = i + 1) begin
                    dac_reg[i] = 0;
                    dac_lev[i] = 0.0;
                end
                dac_reg[9] = 1;
                dac_lev[9] = vdd;
            end
        end
    end

    V(DP_DAC_9) <+ transition(dac_lev[9], 0, tedge, tedge);
    V(DP_DAC_8) <+ transition(dac_lev[8], 0, tedge, tedge);
    V(DP_DAC_7) <+ transition(dac_lev[7], 0, tedge, tedge);
    V(DP_DAC_6) <+ transition(dac_lev[6], 0, tedge, tedge);
    V(DP_DAC_5) <+ transition(dac_lev[5], 0, tedge, tedge);
    V(DP_DAC_4) <+ transition(dac_lev[4], 0, tedge, tedge);
    V(DP_DAC_3) <+ transition(dac_lev[3], 0, tedge, tedge);
    V(DP_DAC_2) <+ transition(dac_lev[2], 0, tedge, tedge);
    V(DP_DAC_1) <+ transition(dac_lev[1], 0, tedge, tedge);
    V(DP_DAC_0) <+ transition(dac_lev[0], 0, tedge, tedge);
    V(RDY)      <+ transition(rdy_level,  0, tedge, tedge);
end

endmodule
