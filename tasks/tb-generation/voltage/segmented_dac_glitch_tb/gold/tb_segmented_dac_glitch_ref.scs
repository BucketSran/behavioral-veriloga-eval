simulator lang=spectre
global 0

Vvdd (vdd 0) vsource dc=0.9
Vvss (vss 0) vsource dc=0.0
Vclk (clk 0) vsource type=pulse val0=0 val1=0.9 delay=1n rise=20p fall=20p width=4n period=10n
Vd3 (d3 0) vsource type=pwl wave=[ \
    0    0.0 \
    10n  0.0 \
    40n  0.0 \
    50n  0.9 \
    80n  0.9 \
    90n  0.0 \
    120n 0.0 \
    130n 0.9 \
    160n 0.9 \
]
Vd2 (d2 0) vsource type=pwl wave=[ \
    0    0.0 \
    20n  0.9 \
    40n  0.0 \
    60n  0.9 \
    80n  0.0 \
    100n 0.9 \
    120n 0.0 \
    140n 0.9 \
    160n 0.0 \
]
Vd1 (d1 0) vsource type=pwl wave=[ \
    0    0.0 \
    30n  0.9 \
    40n  0.0 \
    70n  0.9 \
    80n  0.0 \
    110n 0.9 \
    120n 0.0 \
    150n 0.9 \
    160n 0.0 \
]
Vd0 (d0 0) vsource type=pwl wave=[ \
    0    0.0 \
    10n  0.9 \
    20n  0.0 \
    30n  0.9 \
    40n  0.0 \
    50n  0.9 \
    60n  0.0 \
    70n  0.9 \
    80n  0.0 \
    90n  0.9 \
    100n 0.0 \
    110n 0.9 \
    120n 0.0 \
    130n 0.9 \
    140n 0.0 \
    150n 0.9 \
    160n 0.0 \
]

XDUT (vdd vss clk d3 d2 d1 d0 vout) segmented_dac_glitch_ref

tran tran stop=160n maxstep=100p errpreset=conservative
save clk d3 d2 d1 d0 vout

ahdl_include "segmented_dac_glitch_ref.va"
