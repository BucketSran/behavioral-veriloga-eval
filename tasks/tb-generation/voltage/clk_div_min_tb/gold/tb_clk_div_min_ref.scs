simulator lang=spectre
global 0

Vvdd (VDD 0) vsource dc=0.9
Vvss (VSS 0) vsource dc=0
Vclk (CLK 0) vsource type=pulse val0=0 val1=0.9 delay=1n rise=20p fall=20p width=0.5n period=1n
Vrst (RST_N 0) vsource type=pulse val0=0 val1=0.9 delay=2n rise=20p fall=20p width=38n period=40n

XDUT (VDD VSS CLK RST_N CLK_OUT) clk_div_min

tran tran stop=24n maxstep=20p
save CLK RST_N CLK_OUT

ahdl_include "clk_div_min.va"
