`include "constants.vams"
`include "disciplines.vams"

module sample_hold_step_ref(VDD, VSS, clk, in, out);
    inout VDD, VSS;
    input clk, in;
    output out;
    electrical VDD, VSS, clk, in, out;
    real sampled;

    analog begin
        @(initial_step) sampled = 0.0;
        @(cross(V(clk, VSS) - 0.45, +1))
            sampled = V(in, VSS);
        V(out, VSS) <+ transition(sampled, 0, 20p, 20p);
    end
endmodule
