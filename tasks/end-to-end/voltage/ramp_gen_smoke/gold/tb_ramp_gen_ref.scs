// ramp_gen gold smoke testbench
// 100 MHz clock, RST_N deasserts at 5ns. Thermometer ramp: 0→1→3→7→15.
// Check: code_0..code_3 decoded integer is non-decreasing.
simulator lang=spectre
global 0

ahdl_include "ramp_gen.va"

Vclk   (clk_in 0) vsource type=pulse val0=0 val1=0.9 period=10n width=5n rise=100p fall=100p
Vrst_n (rst_n  0) vsource type=pwl wave=[0 0  4.9n 0  5n 0.9  200n 0.9]

IDUT (clk_in rst_n code_3 code_2 code_1 code_0) ramp_gen vth=0.45 vdd=0.9 tedge=50p

tran tran stop=200n maxstep=5n
save clk_in:2e rst_n:d code_3:d code_2:d code_1:d code_0:d
