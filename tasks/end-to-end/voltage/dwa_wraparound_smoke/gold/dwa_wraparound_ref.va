`include "constants.vams"
`include "disciplines.vams"

`default_transition 10p

module dwa_wraparound_ref (
    input  electrical        clk_i,
    input  electrical        rst_ni,
    input  electrical [3:0]  code_i,
    output electrical [15:0] cell_en_o,
    output electrical [15:0] ptr_o
);

parameter real    vdd      = 0.9;
parameter real    vth      = 0.45;
parameter integer ptr_init = 13;

integer ptr_q;
integer code_q;
integer dist;
integer j;
genvar  i;

real cell_en_val[15:0];
real ptr_val[15:0];

analog begin
    @(initial_step) begin
        ptr_q = ptr_init;
        code_q = 0;
        for (j = 0; j < 16; j = j + 1) begin
            cell_en_val[j] = 0.0;
            ptr_val[j] = (j == ptr_q) ? vdd : 0.0;
        end
    end

    @(cross(V(clk_i) - vth, +1)) begin
        if (V(rst_ni) < vth) begin
            ptr_q = ptr_init;
            code_q = 0;
        end else begin
            code_q = 0;
            if (V(code_i[0]) > vth) code_q = code_q + 1;
            if (V(code_i[1]) > vth) code_q = code_q + 2;
            if (V(code_i[2]) > vth) code_q = code_q + 4;
            if (V(code_i[3]) > vth) code_q = code_q + 8;
            ptr_q = (ptr_q + code_q) % 16;
        end

        for (j = 0; j < 16; j = j + 1) begin
            dist = (ptr_q - j + 16) % 16;
            cell_en_val[j] = ((dist > 0) && (dist <= code_q)) ? vdd : 0.0;
            ptr_val[j] = (j == ptr_q) ? vdd : 0.0;
        end

        $strobe("[dwa_wraparound] t=%.3f ns | code=%2d | ptr=%2d",
                $abstime * 1e9, code_q, ptr_q);
    end

    for (i = 0; i < 16; i = i + 1) begin
        V(cell_en_o[i]) <+ transition(cell_en_val[i]);
        V(ptr_o[i])     <+ transition(ptr_val[i]);
    end
end

endmodule
