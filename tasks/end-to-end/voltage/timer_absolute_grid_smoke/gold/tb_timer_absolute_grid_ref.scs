simulator lang=spectre
global 0

Vvdd (VDD 0) vsource dc=0.9 type=dc
Vvss (VSS 0) vsource dc=0.0 type=dc

IDUT (VDD VSS clk_out) timer_absolute_grid_ref tstart=10n tstep=10n tedge=200p

simulatorOptions options reltol=1e-4 vabstol=1e-6 iabstol=1e-12 temp=27 tnom=27 gmin=1e-12
tran tran stop=75n maxstep=20p errpreset=conservative
save clk_out

ahdl_include "./timer_absolute_grid_ref.va"
