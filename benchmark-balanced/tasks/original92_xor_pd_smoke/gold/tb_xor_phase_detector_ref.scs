// vaEvas/tb_xor_phase_detector/schematic
simulator lang=spectre
global 0

// Power
Vvdd (vdd 0) vsource dc=0.9 type=dc
Vvss (vss 0) vsource dc=0.0 type=dc

// REF: 50MHz clock
Vref (ref 0) vsource type=pulse val0=0 val1=0.9 period=20n width=10n rise=100p fall=100p

// DIV: 50MHz clock with 5ns (90-degree = 5/20*360) phase shift -> XOR output should have ~50% duty cycle
Vdiv (div 0) vsource type=pulse val0=0 val1=0.9 period=20n delay=5n width=10n rise=100p fall=100p

// DUT (port order: VDD VSS REF DIV PD_OUT)
IDUT (vdd vss ref div pd_out) xor_phase_detector vth=0.45 tedge=50p

simulatorOptions options reltol=1e-4 temp=27

tran tran stop=200n maxstep=100p errpreset=conservative

save ref div pd_out

ahdl_include "xor_phase_detector_ref.va"
