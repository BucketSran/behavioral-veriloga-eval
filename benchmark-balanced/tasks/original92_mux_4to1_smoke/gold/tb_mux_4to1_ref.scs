// vaEvas/tb_mux_4to1/schematic
simulator lang=spectre
global 0

// Power
Vvdd (vdd 0) vsource dc=0.9 type=dc
Vvss (vss 0) vsource dc=0.0 type=dc

// Data inputs: constant distinctive voltages on each channel
// D0=0.1V D1=0.3V D2=0.6V D3=0.8V
Vd0 (d0 0) vsource dc=0.1 type=dc
Vd1 (d1 0) vsource dc=0.3 type=dc
Vd2 (d2 0) vsource dc=0.6 type=dc
Vd3 (d3 0) vsource dc=0.8 type=dc

// Select: walk through 0->1->2->3 at 100ns each
Vsel1 (sel1 0) vsource type=pwl wave=[0 0 200e-9 0 201e-9 0.9 400e-9 0.9]
Vsel0 (sel0 0) vsource type=pwl wave=[0 0 100e-9 0 101e-9 0.9 200e-9 0.9 201e-9 0 300e-9 0 301e-9 0.9 400e-9 0.9]

// DUT (port order: VDD VSS D3 D2 D1 D0 SEL1 SEL0 Y)
IDUT (vdd vss d3 d2 d1 d0 sel1 sel0 y) mux_4to1 vth=0.45 tedge=100p

simulatorOptions options reltol=1e-4 temp=27

tran tran stop=420n maxstep=1n errpreset=conservative

save d0 d1 d2 d3 sel1 sel0 y

ahdl_include "./mux_4to1.va"
