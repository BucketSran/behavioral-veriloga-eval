// Ramp generator (thermometer encoding) — EVAS-compatible
// On each rising CLK edge, sets one more bit HIGH (LSB-first thermometer code).
// Only 1 bit changes per step → monotonic decoded code even during transitions.
// Outputs: code_0 .. code_3 (4 thermometer bits → codes 0, 1, 3, 7, 15).

`include "constants.vams"
`include "disciplines.vams"
`default_transition 10p

module ramp_gen(
    input  electrical clk_in,
    input  electrical rst_n,
    output electrical code_3,
    output electrical code_2,
    output electrical code_1,
    output electrical code_0
);

parameter real vth   = 0.45;
parameter real vdd   = 0.9;
parameter real tedge = 50p;

integer step_reg;   // 0..4 thermometer step counter
real    b3, b2, b1, b0;

analog begin
    @(initial_step) begin
        step_reg = 0;
        b3 = 0.0; b2 = 0.0; b1 = 0.0; b0 = 0.0;
        $strobe("[ramp] INIT | step=0");
    end

    @(cross(V(rst_n) - vth, -1)) begin
        step_reg = 0;
        b3 = 0.0; b2 = 0.0; b1 = 0.0; b0 = 0.0;
        $strobe("[ramp] t=%.3f ns | RESET", $abstime*1e9);
    end

    @(cross(V(clk_in) - vth, +1)) begin
        if (V(rst_n) > vth) begin
            if (step_reg == 0) begin b0 = vdd; step_reg = 1; end
            else if (step_reg == 1) begin b1 = vdd; step_reg = 2; end
            else if (step_reg == 2) begin b2 = vdd; step_reg = 3; end
            else if (step_reg == 3) begin b3 = vdd; step_reg = 4; end
            // step_reg == 4: all bits stay high
            $strobe("[ramp] t=%.3f ns | step=%d", $abstime*1e9, step_reg);
        end
    end

    V(code_0) <+ transition(b0, 0, tedge, tedge);
    V(code_1) <+ transition(b1, 0, tedge, tedge);
    V(code_2) <+ transition(b2, 0, tedge, tedge);
    V(code_3) <+ transition(b3, 0, tedge, tedge);
end

endmodule
