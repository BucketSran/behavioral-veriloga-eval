simulator lang=spectre
global 0

Vvdd (VDD 0) vsource dc=0.9
Vvss (VSS 0) vsource dc=0.0
Vref (ref 0) vsource type=pulse val0=0 val1=0.9 delay=1n rise=20p fall=20p width=5n period=10n
Vdiv (div 0) vsource type=pulse val0=0 val1=0.9 delay=3.5n rise=20p fall=20p width=5n period=10n

XDUT (VDD VSS ref div pd_out) xor_phase_ref

tran tran stop=80n maxstep=50p
save ref div pd_out

ahdl_include "xor_phase_ref.va"
