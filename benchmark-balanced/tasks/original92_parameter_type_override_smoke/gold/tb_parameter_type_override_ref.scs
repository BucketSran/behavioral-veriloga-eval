simulator lang=spectre
global 0

VSSSRC (vss 0) vsource dc=0
Xdut (out vss) parameter_type_override_ref vhi=0.72 reps=4 period=10n width=3n trf=50p

tran tran stop=60n maxstep=200p
save out

ahdl_include "parameter_type_override_ref.va"
