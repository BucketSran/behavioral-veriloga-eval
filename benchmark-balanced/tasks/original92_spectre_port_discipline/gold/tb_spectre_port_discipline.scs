simulator lang=spectre
global 0

Vvdd (VDD 0) vsource dc=0.9
Vvss (VSS 0) vsource dc=0
Va (A 0) vsource type=pwl wave=[0 0 20n 0 20.1n 0.9 40n 0.9 40.1n 0 60n 0 60.1n 0.9 80n 0.9]
Vb (B 0) vsource type=pwl wave=[0 0 40n 0 40.1n 0.9 80n 0.9]

XDUT (VDD VSS A B Y) and2_gate

tran tran stop=80n maxstep=100p
save A B Y

ahdl_include "dut_fixed.va"
