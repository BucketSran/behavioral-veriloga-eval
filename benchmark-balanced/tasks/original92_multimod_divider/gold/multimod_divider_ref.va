`include "constants.vams"
`include "disciplines.vams"

module multimod_divider_ref (
    input  electrical clk_in,
    input  electrical mod,
    input  electrical mod_0,
    input  electrical mod_1,
    input  electrical mod_2,
    input  electrical mod_3,
    output electrical prescaler_out
);

parameter real vdd = 0.9;
parameter real vth = 0.45;
parameter real trf = 10p;
parameter real td  = 0p;

integer base_count;
integer target_count;
integer edge_count;
integer pulse_state;

analog begin
    @(initial_step) begin
        base_count = 1;
        target_count = 1;
        edge_count = 0;
        pulse_state = 0;
    end

    @(cross(V(clk_in) - vth, +1)) begin
        base_count = (V(mod_0) > vth ? 1 : 0)
                   + (V(mod_1) > vth ? 2 : 0)
                   + (V(mod_2) > vth ? 4 : 0)
                   + (V(mod_3) > vth ? 8 : 0);

        if (base_count < 1)
            base_count = 1;

        target_count = base_count + (V(mod) > vth ? 1 : 0);
        if (target_count < 1)
            target_count = 1;

        edge_count = edge_count + 1;
        if (edge_count >= target_count) begin
            edge_count = 0;
            pulse_state = 1;
        end else begin
            pulse_state = 0;
        end

        $strobe("[multimod_divider] t=%.3f ns | base=%d | target=%d | edge_count=%d | pulse=%d",
            $abstime * 1e9, base_count, target_count, edge_count, pulse_state);
    end

    V(prescaler_out) <+ transition(pulse_state ? vdd : 0.0, td, trf, trf);
end

endmodule
