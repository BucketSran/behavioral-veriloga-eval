`include "constants.vams"
`include "disciplines.vams"

module differential_voltage_output_ref (
    inout  electrical VDD,
    inout  electrical VSS,
    output electrical outp,
    output electrical outn
);

parameter real vcm = 0.2 from [0:inf);
parameter real diff_lo = 0.1 from [0:inf);
parameter real diff_hi = 0.5 from [0:inf);
parameter real tedge = 60p from (0:inf);

real diff_target;
real next_t;
integer state_q;

analog begin
    @(initial_step) begin
        state_q = 0;
        diff_target = diff_lo;
        next_t = 20n;
    end

    @(timer(next_t)) begin
        state_q = state_q + 1;
        if (state_q == 1) begin
            diff_target = diff_hi;
            next_t = 40n;
        end else begin
            diff_target = diff_lo;
            next_t = 1e9;
        end
    end

    V(outn, VSS) <+ vcm;
    V(outp, outn) <+ transition(diff_target, 0.0, tedge, tedge);
end

endmodule
