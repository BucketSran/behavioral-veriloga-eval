simulator lang=spectre
global 0

ahdl_include "dut.va"

Vvdd (vdd 0) vsource dc=0.9
Vvss (vss 0) vsource dc=0
Vsig (sensor_level 0) vsource type=pwl wave=[ 0 0.1 20n 0.1 40n 0.45 70n 0.45 90n 0.82 120n 0.82 ]

XDUT (sensor_level vdd vss inside_window below_window above_window) balanced_window_detector

tran tran stop=120n maxstep=500p
save sensor_level inside_window below_window above_window
