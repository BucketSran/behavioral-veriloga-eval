simulator lang=spectre
global 0

Vvdd (VDD 0) vsource dc=0.9 type=dc
Vvss (VSS 0) vsource dc=0.0 type=dc
Vvin (vin 0) vsource type=pwl wave=[0 0 45n 0.9 90n 0]

IDUT (VDD VSS vin out) cross_hysteresis_window_ref

simulatorOptions options reltol=1e-4 vabstol=1e-6 iabstol=1e-12 temp=27 tnom=27 gmin=1e-12
tran tran stop=90n maxstep=20p errpreset=conservative
save vin out

ahdl_include "./cross_hysteresis_window_ref.va"
