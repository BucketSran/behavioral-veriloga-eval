`include "constants.vams"
`include "disciplines.vams"

module therm2bin_ref (
    input electrical therm_0,
    input electrical therm_1,
    input electrical therm_2,
    input electrical therm_3,
    input electrical therm_4,
    input electrical therm_5,
    input electrical therm_6,
    input electrical therm_7,
    input electrical therm_8,
    input electrical therm_9,
    input electrical therm_10,
    input electrical therm_11,
    input electrical therm_12,
    input electrical therm_13,
    input electrical therm_14,
    output electrical bin_0,
    output electrical bin_1,
    output electrical bin_2,
    output electrical bin_3
);

parameter real vdd = 0.9;
parameter real vth = 0.45;
parameter real trf = 10p;
parameter real td  = 0p;

integer count;
integer bit0;
integer bit1;
integer bit2;
integer bit3;

analog begin
    count = 0;
    count = count + (V(therm_0)  > vth ? 1 : 0);
    count = count + (V(therm_1)  > vth ? 1 : 0);
    count = count + (V(therm_2)  > vth ? 1 : 0);
    count = count + (V(therm_3)  > vth ? 1 : 0);
    count = count + (V(therm_4)  > vth ? 1 : 0);
    count = count + (V(therm_5)  > vth ? 1 : 0);
    count = count + (V(therm_6)  > vth ? 1 : 0);
    count = count + (V(therm_7)  > vth ? 1 : 0);
    count = count + (V(therm_8)  > vth ? 1 : 0);
    count = count + (V(therm_9)  > vth ? 1 : 0);
    count = count + (V(therm_10) > vth ? 1 : 0);
    count = count + (V(therm_11) > vth ? 1 : 0);
    count = count + (V(therm_12) > vth ? 1 : 0);
    count = count + (V(therm_13) > vth ? 1 : 0);
    count = count + (V(therm_14) > vth ? 1 : 0);

    if (count < 0)
        count = 0;
    if (count > 15)
        count = 15;

    bit0 =  count       & 1;
    bit1 = (count >> 1) & 1;
    bit2 = (count >> 2) & 1;
    bit3 = (count >> 3) & 1;

    V(bin_0) <+ transition(bit0 ? vdd : 0.0, td, trf, trf);
    V(bin_1) <+ transition(bit1 ? vdd : 0.0, td, trf, trf);
    V(bin_2) <+ transition(bit2 ? vdd : 0.0, td, trf, trf);
    V(bin_3) <+ transition(bit3 ? vdd : 0.0, td, trf, trf);
end

endmodule
