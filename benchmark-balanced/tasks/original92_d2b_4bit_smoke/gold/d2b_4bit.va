// 4-bit static analog-to-binary converter — EVAS-compatible
// Uses @(timer) to periodically re-quantize VIN → 4-bit code.
// Each bit stored as a piecewise-constant real variable.

`include "constants.vams"
`include "disciplines.vams"
`default_transition 10p

module d2b_4bit(
    inout  electrical VDD,
    inout  electrical VSS,
    input  electrical VIN,
    output electrical DOUT3,
    output electrical DOUT2,
    output electrical DOUT1,
    output electrical DOUT0
);

parameter real tedge = 50p;
parameter real dt    = 2n;     // update rate

real    b3, b2, b1, b0;
integer code;
real    vstep;

analog begin
    @(initial_step) begin
        b3 = 0.0; b2 = 0.0; b1 = 0.0; b0 = 0.0;
        $strobe("[d2b] INIT");
    end

    @(timer(dt)) begin
        vstep = V(VDD) / 16.0;
        code  = floor(V(VIN) / vstep);
        if (code < 0)  code = 0;
        if (code > 15) code = 15;
        b3 = ((code >> 3) & 1) ? V(VDD) : V(VSS);
        b2 = ((code >> 2) & 1) ? V(VDD) : V(VSS);
        b1 = ((code >> 1) & 1) ? V(VDD) : V(VSS);
        b0 = ((code >> 0) & 1) ? V(VDD) : V(VSS);
        $strobe("[d2b] t=%.3f ns | vin=%.4gV | code=%d", $abstime*1e9, V(VIN), code);
    end

    V(DOUT3) <+ transition(b3, 0, tedge, tedge);
    V(DOUT2) <+ transition(b2, 0, tedge, tedge);
    V(DOUT1) <+ transition(b1, 0, tedge, tedge);
    V(DOUT0) <+ transition(b0, 0, tedge, tedge);
end

endmodule
