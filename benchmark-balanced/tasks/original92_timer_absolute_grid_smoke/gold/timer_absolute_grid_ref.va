`include "constants.vams"
`include "disciplines.vams"

module timer_absolute_grid_ref (
    inout  electrical VDD,
    inout  electrical VSS,
    output electrical clk_out
);

parameter real tstart = 10n from [0:inf);
parameter real tstep  = 10n from (0:inf);
parameter real tedge  = 200p from (0:inf);

real vh;
real vl;
real next_t;
integer clk_state;

analog begin
    vh = V(VDD);
    vl = V(VSS);

    @(initial_step) begin
        clk_state = 0;
        next_t = tstart;
    end

    @(timer(next_t)) begin
        clk_state = 1 - clk_state;
        next_t = next_t + tstep;
    end

    V(clk_out) <+ vl + (vh - vl) * transition(clk_state ? 1.0 : 0.0, 0.0, tedge, tedge);
end

endmodule
