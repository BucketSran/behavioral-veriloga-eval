`include "constants.vams"
`include "disciplines.vams"

module _va_d2b_4b (VDD, VSS, VIN, DOUT3, DOUT2, DOUT1, DOUT0);
    inout VDD;
    inout VSS;
    input VIN;
    output DOUT3;
    output DOUT2;
    output DOUT1;
    output DOUT0;
    electrical VDD, VSS, VIN, DOUT3, DOUT2, DOUT1, DOUT0;

    parameter real vdd_level = 1.8 from (0:inf);
    parameter real vss_level = 0.0 from [0:inf);
    parameter real dt = 0 from [0:inf);
    parameter real tedge = 1n from (0:inf);

    real vin_norm;
    integer code;
    integer b3, b2, b1, b0;
    real vout3, vout2, vout1, vout0;
    real scaled;

    analog begin
        // Normalize input to 0-1 range based on VDD/VSS
        vin_norm = (V(VIN) - V(VSS)) / (V(VDD) - V(VSS));

        // Clamp to valid range
        if (vin_norm < 0.0)
            vin_norm = 0.0;
        else if (vin_norm > 1.0)
            vin_norm = 1.0;

        // Convert to 4-bit code (0-15)
        scaled = vin_norm * 16.0;
        code = 0;
        if (scaled >= 15.5)
            code = 15;
        else if (scaled >= 14.5)
            code = 14;
        else if (scaled >= 13.5)
            code = 13;
        else if (scaled >= 12.5)
            code = 12;
        else if (scaled >= 11.5)
            code = 11;
        else if (scaled >= 10.5)
            code = 10;
        else if (scaled >= 9.5)
            code = 9;
        else if (scaled >= 8.5)
            code = 8;
        else if (scaled >= 7.5)
            code = 7;
        else if (scaled >= 6.5)
            code = 6;
        else if (scaled >= 5.5)
            code = 5;
        else if (scaled >= 4.5)
            code = 4;
        else if (scaled >= 3.5)
            code = 3;
        else if (scaled >= 2.5)
            code = 2;
        else if (scaled >= 1.5)
            code = 1;
        else if (scaled >= 0.5)
            code = 0;
        else
            code = 0;

        // Extract bits using arithmetic
        b3 = code / 8;
        b2 = (code - b3 * 8) / 4;
        b1 = (code - b3 * 8 - b2 * 4) / 2;
        b0 = code - b3 * 8 - b2 * 4 - b1 * 2;

        // Convert bits to voltage levels
        vout3 = b3 ? vdd_level : vss_level;
        vout2 = b2 ? vdd_level : vss_level;
        vout1 = b1 ? vdd_level : vss_level;
        vout0 = b0 ? vdd_level : vss_level;

        // Output with transitions
        V(DOUT3) <+ transition(vout3, dt, tedge, tedge);
        V(DOUT2) <+ transition(vout2, dt, tedge, tedge);
        V(DOUT1) <+ transition(vout1, dt, tedge, tedge);
        V(DOUT0) <+ transition(vout0, dt, tedge, tedge);
    end
endmodule
