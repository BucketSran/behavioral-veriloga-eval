simulator lang=spectre
global 0

ahdl_include "serializer_8b.va"

// Power supplies
Vdd (vdd 0) vsource dc=0.9
Vss (vss 0) vsource dc=0

// Parallel data inputs - 8'b10100101 = 0xA5 (MSB-first: 1,0,1,0,0,1,0,1)
Vd7 (d7 0) vsource dc=0.9
Vd6 (d6 0) vsource dc=0
Vd5 (d5 0) vsource dc=0.9
Vd4 (d4 0) vsource dc=0
Vd3 (d3 0) vsource dc=0
Vd2 (d2 0) vsource dc=0.9
Vd1 (d1 0) vsource dc=0
Vd0 (d0 0) vsource dc=0.9

// Load pulse - active high, loads data at rising edge
Vload (load 0) vsource type=pulse val0=0 val1=0.9 period=100n rise=1n fall=1n width=10n delay=5n

// Clock - 10MHz, 100ns period
Vclk (clk 0) vsource type=pulse val0=0 val1=0.9 period=10n rise=1n fall=1n width=4n delay=20n

// DUT instance
XDUT (vdd vss d7 d6 d5 d4 d3 d2 d1 d0 load clk sout) serializer_8b

// Save statements for required signals
save load
save clk
save sout
save d7
save d6
save d5
save d4
save d3
save d2
save d1
save d0

// Transient analysis
tran tran stop=300n maxstep=1n
