`include "constants.vams"
`include "disciplines.vams"

module serializer_8b (vdd, vss, d7, d6, d5, d4, d3, d2, d1, d0, load, clk, sout);
    inout vdd, vss;
    input d7, d6, d5, d4, d3, d2, d1, d0;
    input load, clk;
    output sout;
    electrical vdd, vss, d7, d6, d5, d4, d3, d2, d1, d0, load, clk, sout;

    parameter real vth = 0.45;
    parameter real tedge = 100p;

    integer shift_reg;
    integer bit_count;
    integer load_pending;
    real vhi, vlo;
    real sout_val;

    analog begin
        @(initial_step) begin
            shift_reg = 0;
            bit_count = 0;
            load_pending = 0;
            sout_val = 0.0;
        end

        vhi = V(vdd);
        vlo = V(vss);

        // Detect rising edge of load
        @(cross(V(load) - vth, 1)) begin
            // Latch d7..d0 into shift register, MSB first
            shift_reg = 0;
            if (V(d7) > vth) shift_reg = shift_reg + 128;
            if (V(d6) > vth) shift_reg = shift_reg + 64;
            if (V(d5) > vth) shift_reg = shift_reg + 32;
            if (V(d4) > vth) shift_reg = shift_reg + 16;
            if (V(d3) > vth) shift_reg = shift_reg + 8;
            if (V(d2) > vth) shift_reg = shift_reg + 4;
            if (V(d1) > vth) shift_reg = shift_reg + 2;
            if (V(d0) > vth) shift_reg = shift_reg + 1;
            bit_count = 0;
            load_pending = 1;
            // Do NOT output yet - wait for first CLK edge
        end

        // Detect rising edge of clk
        @(cross(V(clk) - vth, 1)) begin
            if (V(load) > vth) begin
                // CLK during LOAD - do nothing, wait for LOAD to fall
            end else if (load_pending) begin
                // First CLK after LOAD fell - output MSB
                if (shift_reg >= 128) begin
                    sout_val = vhi;
                    shift_reg = shift_reg - 128;
                end else begin
                    sout_val = vlo;
                end
                shift_reg = shift_reg * 2; // shift left, MSB consumed
                bit_count = bit_count + 1;
                load_pending = 0;
            end else if (bit_count < 8) begin
                // Subsequent CLK edges - output next bit
                if (shift_reg >= 128) begin
                    sout_val = vhi;
                    shift_reg = shift_reg - 128;
                end else begin
                    sout_val = vlo;
                end
                shift_reg = shift_reg * 2; // shift left
                bit_count = bit_count + 1;
            end
            // After 8 bits, behavior undefined until next load
        end

        V(sout) <+ transition(sout_val, 0, tedge);
    end
endmodule
