simulator lang=spectre
global 0

Vvdd (vdd 0) vsource dc=0.9

Vclk (clk_i 0) vsource type=pulse val0=0 val1=0.9 period=10n rise=100p fall=100p width=5n

Vrst (rst_ni 0) vsource type=pwl wave=[0 0 15n 0 15.1n 0.9]

Vcode (code_in 0) vsource type=pwl wave=[0 0 20n 0 20.1n 0.2 30n 0.2 30.1n 0.3 40n 0.3 40.1n 0.4 50n 0.4 50.1n 0.57 60n 0.57 60.1n 0.68 70n 0.68 70.1n 0.8 80n 0.8 80.1n 0.12 100n 0.12]

Xv2b (code_in code_3 code_2 code_1 code_0 vdd 0) v2b_4b

Xdwa (clk_i rst_ni code_3 code_2 code_1 code_0 \
      cell_en_15 cell_en_14 cell_en_13 cell_en_12 \
      cell_en_11 cell_en_10 cell_en_9 cell_en_8 \
      cell_en_7 cell_en_6 cell_en_5 cell_en_4 \
      cell_en_3 cell_en_2 cell_en_1 cell_en_0 \
      ptr_15 ptr_14 ptr_13 ptr_12 \
      ptr_11 ptr_10 ptr_9 ptr_8 \
      ptr_7 ptr_6 ptr_5 ptr_4 \
      ptr_3 ptr_2 ptr_1 ptr_0 \
      vdd 0) dwa_ptr_gen

save clk_i rst_ni
save cell_en_15 cell_en_14 cell_en_13 cell_en_12
save cell_en_11 cell_en_10 cell_en_9 cell_en_8
save cell_en_7 cell_en_6 cell_en_5 cell_en_4
save cell_en_3 cell_en_2 cell_en_1 cell_en_0
save ptr_15 ptr_14 ptr_13 ptr_12
save ptr_11 ptr_10 ptr_9 ptr_8
save ptr_7 ptr_6 ptr_5 ptr_4
save ptr_3 ptr_2 ptr_1 ptr_0

tran tran stop=100n maxstep=2n

ahdl_include "v2b_4b.va"
ahdl_include "dwa_ptr_gen.va"
