`include "constants.vams"
`include "disciplines.vams"

module cppll_timer_ref (VDD, VSS, ref_clk, fb_clk, dco_clk, vctrl_mon, lock);
    inout VDD;
    inout VSS;
    input ref_clk;
    output fb_clk;
    output dco_clk;
    output vctrl_mon;
    output lock;

    electrical VDD, VSS, ref_clk, fb_clk, dco_clk, vctrl_mon, lock;

    // Parameters
    parameter real vth = 0.9 from (0:inf);
    parameter real tdel = 1p from (0:inf);
    parameter real tr = 100p from (0:inf);
    parameter real tf = 100p from (0:inf);
    parameter real kp = 2e-5 from (0:inf);
    parameter real ki = 1e-7 from (0:inf);
    parameter real fmin = 10e6 from (0:inf);
    parameter real fmax = 500e6 from (0:inf);
    parameter integer div_ratio = 4 from (1:inf);
    parameter real lock_thr = 0.02 from (0:inf);
    parameter integer lock_cnt_max = 50 from (1:inf);

    // Internal variables
    integer ref_edge_cnt;
    integer fb_edge_cnt;
    integer div_cnt;
    integer lock_cnt;
    integer locked;
    integer dco_state;
    integer fb_state;
    real phase_err;
    real vctrl;
    real vctrl_prop;
    real vctrl_int;
    real t_dco;
    real t_dco_nom;
    real t_next;
    real vdd_level;
    real vss_level;
    real ref_period_est;
    real fb_period_est;
    real freq_err;
    real last_ref_time;
    real last_fb_time;
    real ref_period_meas;
    real fb_period_meas;

    analog begin
        @(initial_step) begin
            ref_edge_cnt = 0;
            fb_edge_cnt = 0;
            div_cnt = 0;
            lock_cnt = 0;
            locked = 0;
            phase_err = 0.0;
            vctrl = 0.9;
            vctrl_prop = 0.0;
            vctrl_int = 0.0;
            t_dco = 5e-9;
            t_dco_nom = 5e-9;
            t_next = 1e-9;
            vdd_level = 1.8;
            vss_level = 0.0;
            ref_period_est = 20e-9;
            fb_period_est = 20e-9;
            freq_err = 0.0;
            dco_state = 0;
            fb_state = 0;
            last_ref_time = 0.0;
            last_fb_time = 0.0;
            ref_period_meas = 20e-9;
            fb_period_meas = 20e-9;
        end

        // Sample supply levels
        vdd_level = V(VDD);
        vss_level = V(VSS);

        // Reference clock edge detection
        @(cross(V(ref_clk) - vth, 1)) begin
            ref_edge_cnt = ref_edge_cnt + 1;
            ref_period_meas = $abstime - last_ref_time;
            last_ref_time = $abstime;
            ref_period_est = ref_period_meas;
        end

        // DCO timer-based oscillator
        @(timer(t_next)) begin
            // Toggle DCO state
            dco_state = !dco_state;

            // Increment divider counter on each DCO edge
            div_cnt = div_cnt + 1;

            // Calculate DCO period based on vctrl
            // vctrl=0 -> fmin (long period), vctrl=vdd -> fmax (short period)
            t_dco = 1.0 / (fmin + (fmax - fmin) * (vctrl / vdd_level));

            // Clamp period
            if (t_dco < 1.0 / fmax) t_dco = 1.0 / fmax;
            if (t_dco > 1.0 / fmin) t_dco = 1.0 / fmin;

            // Schedule next DCO edge
            t_next = $abstime + t_dco;

            // Generate divided feedback clock - toggle every div_ratio/2 DCO edges
            if (div_cnt >= div_ratio) begin
                div_cnt = 0;
                fb_state = !fb_state;
                fb_edge_cnt = fb_edge_cnt + 1;
                fb_period_meas = $abstime - last_fb_time;
                last_fb_time = $abstime;
                fb_period_est = fb_period_meas;
            end
        end

        // Phase/frequency detector and loop filter
        @(cross(V(ref_clk) - vth, 1)) begin
            // Frequency error: positive if fb too slow (period too long)
            freq_err = (fb_period_est - ref_period_est) / ref_period_est;

            // Phase error based on frequency error
            phase_err = freq_err;

            // PI controller
            vctrl_prop = kp * phase_err;
            vctrl_int = vctrl_int + ki * phase_err;

            // Clamp integrator
            if (vctrl_int > vdd_level) vctrl_int = vdd_level;
            if (vctrl_int < -vdd_level) vctrl_int = -vdd_level;

            // Total control voltage
            vctrl = 0.5 * vdd_level + vctrl_prop + vctrl_int;

            // Clamp control voltage to supply rails
            if (vctrl > vdd_level) vctrl = vdd_level;
            if (vctrl < vss_level) vctrl = vss_level;

            // Lock detection based on small frequency error
            if (abs(freq_err) < lock_thr) begin
                lock_cnt = lock_cnt + 1;
                if (lock_cnt >= lock_cnt_max) locked = 1;
            end else begin
                lock_cnt = 0;
                locked = 0;
            end
        end

        // Output assignments with transition
        V(dco_clk) <+ transition(dco_state ? vdd_level : vss_level, tdel, tr, tf);
        V(fb_clk) <+ transition(fb_state ? vdd_level : vss_level, tdel, tr, tf);
        V(vctrl_mon) <+ transition(vctrl, tdel, tr, tf);
        V(lock) <+ transition(locked ? vdd_level : vss_level, tdel, tr, tf);
    end
endmodule
