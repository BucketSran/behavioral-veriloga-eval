simulator lang=spectre
global 0

ahdl_include "dwa_wraparound_ref.va"

// Clock: 10ns period, 50% duty cycle
Vclk (clk_i 0) vsource type=pulse val0=0 val1=1.8 period=10n rise=0.1n fall=0.1n width=4.9n

// Reset: active low, release at 5ns
Vrst (rst_ni 0) vsource type=pwl wave=[0n 0 5n 0 5.1n 1.8]

// Code inputs: drive values to force multiple wraparounds from initial ptr=13
// Need wrap_events >= 2 and split_wrap_rows >= 2
// Sequence: 5 (13->2, no wrap), 7 (2->9, no wrap), 10 (9->3, wraps 15->0), 6 (3->9, no wrap), 8 (9->1, wraps 15->0), 12 (1->13, wraps 15->0), 4 (13->1, wraps 15->0), 15 (1->0, wraps 15->0)
// This gives multiple wraps and split windows
Vcode0 (code_0 0) vsource type=pwl wave=[0n 0 9n 0 9.1n 1.8 19n 1.8 19.1n 0 29n 0 29.1n 0 39n 0 39.1n 0 49n 0 49.1n 1.8 59n 1.8 59.1n 0 69n 0 69.1n 0 79n 0 79.1n 1.8 89n 1.8]
Vcode1 (code_1 0) vsource type=pwl wave=[0n 0 9n 0 9.1n 0 19n 0 19.1n 1.8 29n 1.8 29.1n 0 39n 0 39.1n 1.8 49n 1.8 49.1n 0 59n 0 59.1n 0 69n 0 69.1n 0 79n 0 79.1n 1.8 89n 1.8]
Vcode2 (code_2 0) vsource type=pwl wave=[0n 0 9n 0 9.1n 1.8 19n 1.8 19.1n 1.8 29n 1.8 29.1n 0 39n 0 39.1n 0 49n 0 49.1n 0 59n 0 59.1n 0 69n 0 69.1n 0 79n 0 79.1n 0 89n 0]
Vcode3 (code_3 0) vsource type=pwl wave=[0n 0 9n 0 9.1n 0 19n 0 19.1n 0 29n 0 29.1n 0 39n 0 39.1n 0 49n 0 49.1n 0 59n 0 59.1n 0 69n 0 69.1n 0 79n 0 79.1n 1.8 89n 1.8]

// DUT instance - single line to avoid uncontinued multiline instance error
XDUT (clk_i rst_ni code_0 code_1 code_2 code_3 cell_en_0 cell_en_1 cell_en_2 cell_en_3 cell_en_4 cell_en_5 cell_en_6 cell_en_7 cell_en_8 cell_en_9 cell_en_10 cell_en_11 cell_en_12 cell_en_13 cell_en_14 cell_en_15 ptr_0 ptr_1 ptr_2 ptr_3 ptr_4 ptr_5 ptr_6 ptr_7 ptr_8 ptr_9 ptr_10 ptr_11 ptr_12 ptr_13 ptr_14 ptr_15) dwa_wraparound_ref

// Transient analysis
tran tran stop=90n maxstep=0.1n

// Save all required signals
save clk_i rst_ni
save code_0 code_1 code_2 code_3
save cell_en_0 cell_en_1 cell_en_2 cell_en_3 cell_en_4 cell_en_5 cell_en_6 cell_en_7
save cell_en_8 cell_en_9 cell_en_10 cell_en_11 cell_en_12 cell_en_13 cell_en_14 cell_en_15
save ptr_0 ptr_1 ptr_2 ptr_3 ptr_4 ptr_5 ptr_6 ptr_7
save ptr_8 ptr_9 ptr_10 ptr_11 ptr_12 ptr_13 ptr_14 ptr_15
