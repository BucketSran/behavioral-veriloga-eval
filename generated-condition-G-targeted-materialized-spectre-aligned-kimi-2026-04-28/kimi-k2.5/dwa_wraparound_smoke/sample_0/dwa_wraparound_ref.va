`include "constants.vams"
`include "disciplines.vams"

module dwa_wraparound_ref (clk_i, rst_ni, code_i_0, code_i_1, code_i_2, code_i_3,
                           cell_en_o_0, cell_en_o_1, cell_en_o_2, cell_en_o_3,
                           cell_en_o_4, cell_en_o_5, cell_en_o_6, cell_en_o_7,
                           cell_en_o_8, cell_en_o_9, cell_en_o_10, cell_en_o_11,
                           cell_en_o_12, cell_en_o_13, cell_en_o_14, cell_en_o_15,
                           ptr_o_0, ptr_o_1, ptr_o_2, ptr_o_3, ptr_o_4, ptr_o_5,
                           ptr_o_6, ptr_o_7, ptr_o_8, ptr_o_9, ptr_o_10, ptr_o_11,
                           ptr_o_12, ptr_o_13, ptr_o_14, ptr_o_15);
    input clk_i, rst_ni, code_i_0, code_i_1, code_i_2, code_i_3;
    output cell_en_o_0, cell_en_o_1, cell_en_o_2, cell_en_o_3;
    output cell_en_o_4, cell_en_o_5, cell_en_o_6, cell_en_o_7;
    output cell_en_o_8, cell_en_o_9, cell_en_o_10, cell_en_o_11;
    output cell_en_o_12, cell_en_o_13, cell_en_o_14, cell_en_o_15;
    output ptr_o_0, ptr_o_1, ptr_o_2, ptr_o_3, ptr_o_4, ptr_o_5;
    output ptr_o_6, ptr_o_7, ptr_o_8, ptr_o_9, ptr_o_10, ptr_o_11;
    output ptr_o_12, ptr_o_13, ptr_o_14, ptr_o_15;
    electrical clk_i, rst_ni, code_i_0, code_i_1, code_i_2, code_i_3;
    electrical cell_en_o_0, cell_en_o_1, cell_en_o_2, cell_en_o_3;
    electrical cell_en_o_4, cell_en_o_5, cell_en_o_6, cell_en_o_7;
    electrical cell_en_o_8, cell_en_o_9, cell_en_o_10, cell_en_o_11;
    electrical cell_en_o_12, cell_en_o_13, cell_en_o_14, cell_en_o_15;
    electrical ptr_o_0, ptr_o_1, ptr_o_2, ptr_o_3, ptr_o_4, ptr_o_5;
    electrical ptr_o_6, ptr_o_7, ptr_o_8, ptr_o_9, ptr_o_10, ptr_o_11;
    electrical ptr_o_12, ptr_o_13, ptr_o_14, ptr_o_15;

    parameter real vth = 0.9;
    parameter real vhi = 1.8;
    parameter real vlo = 0.0;
    parameter real tr = 0.1n;
    parameter real tf = 0.1n;

    integer ptr;
    integer code;
    integer i;
    integer cell_idx;
    integer ptr_array_0;
    integer ptr_array_1;
    integer ptr_array_2;
    integer ptr_array_3;
    integer ptr_array_4;
    integer ptr_array_5;
    integer ptr_array_6;
    integer ptr_array_7;
    integer ptr_array_8;
    integer ptr_array_9;
    integer ptr_array_10;
    integer ptr_array_11;
    integer ptr_array_12;
    integer ptr_array_13;
    integer ptr_array_14;
    integer ptr_array_15;
    integer cell_en_array_0;
    integer cell_en_array_1;
    integer cell_en_array_2;
    integer cell_en_array_3;
    integer cell_en_array_4;
    integer cell_en_array_5;
    integer cell_en_array_6;
    integer cell_en_array_7;
    integer cell_en_array_8;
    integer cell_en_array_9;
    integer cell_en_array_10;
    integer cell_en_array_11;
    integer cell_en_array_12;
    integer cell_en_array_13;
    integer cell_en_array_14;
    integer cell_en_array_15;

    analog begin
        @(initial_step) begin
            ptr = 13;
            ptr_array_0 = 0;
            ptr_array_1 = 0;
            ptr_array_2 = 0;
            ptr_array_3 = 0;
            ptr_array_4 = 0;
            ptr_array_5 = 0;
            ptr_array_6 = 0;
            ptr_array_7 = 0;
            ptr_array_8 = 0;
            ptr_array_9 = 0;
            ptr_array_10 = 0;
            ptr_array_11 = 0;
            ptr_array_12 = 0;
            ptr_array_13 = 1;
            ptr_array_14 = 0;
            ptr_array_15 = 0;
            cell_en_array_0 = 0;
            cell_en_array_1 = 0;
            cell_en_array_2 = 0;
            cell_en_array_3 = 0;
            cell_en_array_4 = 0;
            cell_en_array_5 = 0;
            cell_en_array_6 = 0;
            cell_en_array_7 = 0;
            cell_en_array_8 = 0;
            cell_en_array_9 = 0;
            cell_en_array_10 = 0;
            cell_en_array_11 = 0;
            cell_en_array_12 = 0;
            cell_en_array_13 = 0;
            cell_en_array_14 = 0;
            cell_en_array_15 = 0;
        end

        @(cross(V(rst_ni) - vth, -1)) begin
            ptr = 13;
            ptr_array_0 = 0;
            ptr_array_1 = 0;
            ptr_array_2 = 0;
            ptr_array_3 = 0;
            ptr_array_4 = 0;
            ptr_array_5 = 0;
            ptr_array_6 = 0;
            ptr_array_7 = 0;
            ptr_array_8 = 0;
            ptr_array_9 = 0;
            ptr_array_10 = 0;
            ptr_array_11 = 0;
            ptr_array_12 = 0;
            ptr_array_13 = 1;
            ptr_array_14 = 0;
            ptr_array_15 = 0;
            cell_en_array_0 = 0;
            cell_en_array_1 = 0;
            cell_en_array_2 = 0;
            cell_en_array_3 = 0;
            cell_en_array_4 = 0;
            cell_en_array_5 = 0;
            cell_en_array_6 = 0;
            cell_en_array_7 = 0;
            cell_en_array_8 = 0;
            cell_en_array_9 = 0;
            cell_en_array_10 = 0;
            cell_en_array_11 = 0;
            cell_en_array_12 = 0;
            cell_en_array_13 = 0;
            cell_en_array_14 = 0;
            cell_en_array_15 = 0;
        end

        @(cross(V(clk_i) - vth, +1)) begin
            if (V(rst_ni) > vth) begin
                code = 0;
                if (V(code_i_0) > vth) code = code + 1;
                if (V(code_i_1) > vth) code = code + 2;
                if (V(code_i_2) > vth) code = code + 4;
                if (V(code_i_3) > vth) code = code + 8;

                ptr = ptr + code;
                if (ptr >= 16) ptr = ptr - 16;

                ptr_array_0 = 0;
                ptr_array_1 = 0;
                ptr_array_2 = 0;
                ptr_array_3 = 0;
                ptr_array_4 = 0;
                ptr_array_5 = 0;
                ptr_array_6 = 0;
                ptr_array_7 = 0;
                ptr_array_8 = 0;
                ptr_array_9 = 0;
                ptr_array_10 = 0;
                ptr_array_11 = 0;
                ptr_array_12 = 0;
                ptr_array_13 = 0;
                ptr_array_14 = 0;
                ptr_array_15 = 0;
                cell_en_array_0 = 0;
                cell_en_array_1 = 0;
                cell_en_array_2 = 0;
                cell_en_array_3 = 0;
                cell_en_array_4 = 0;
                cell_en_array_5 = 0;
                cell_en_array_6 = 0;
                cell_en_array_7 = 0;
                cell_en_array_8 = 0;
                cell_en_array_9 = 0;
                cell_en_array_10 = 0;
                cell_en_array_11 = 0;
                cell_en_array_12 = 0;
                cell_en_array_13 = 0;
                cell_en_array_14 = 0;
                cell_en_array_15 = 0;

                if (ptr == 0) ptr_array_0 = 1;
                else if (ptr == 1) ptr_array_1 = 1;
                else if (ptr == 2) ptr_array_2 = 1;
                else if (ptr == 3) ptr_array_3 = 1;
                else if (ptr == 4) ptr_array_4 = 1;
                else if (ptr == 5) ptr_array_5 = 1;
                else if (ptr == 6) ptr_array_6 = 1;
                else if (ptr == 7) ptr_array_7 = 1;
                else if (ptr == 8) ptr_array_8 = 1;
                else if (ptr == 9) ptr_array_9 = 1;
                else if (ptr == 10) ptr_array_10 = 1;
                else if (ptr == 11) ptr_array_11 = 1;
                else if (ptr == 12) ptr_array_12 = 1;
                else if (ptr == 13) ptr_array_13 = 1;
                else if (ptr == 14) ptr_array_14 = 1;
                else if (ptr == 15) ptr_array_15 = 1;

                for (i = 0; i < code; i = i + 1) begin
                    cell_idx = ptr - code + 1 + i;
                    if (cell_idx < 0) cell_idx = cell_idx + 16;
                    if (cell_idx >= 16) cell_idx = cell_idx - 16;
                    if (cell_idx == 0) cell_en_array_0 = 1;
                    else if (cell_idx == 1) cell_en_array_1 = 1;
                    else if (cell_idx == 2) cell_en_array_2 = 1;
                    else if (cell_idx == 3) cell_en_array_3 = 1;
                    else if (cell_idx == 4) cell_en_array_4 = 1;
                    else if (cell_idx == 5) cell_en_array_5 = 1;
                    else if (cell_idx == 6) cell_en_array_6 = 1;
                    else if (cell_idx == 7) cell_en_array_7 = 1;
                    else if (cell_idx == 8) cell_en_array_8 = 1;
                    else if (cell_idx == 9) cell_en_array_9 = 1;
                    else if (cell_idx == 10) cell_en_array_10 = 1;
                    else if (cell_idx == 11) cell_en_array_11 = 1;
                    else if (cell_idx == 12) cell_en_array_12 = 1;
                    else if (cell_idx == 13) cell_en_array_13 = 1;
                    else if (cell_idx == 14) cell_en_array_14 = 1;
                    else if (cell_idx == 15) cell_en_array_15 = 1;
                end
            end
        end

        V(ptr_o_0) <+ transition(ptr_array_0 ? vhi : vlo, 0, tr, tf);
        V(ptr_o_1) <+ transition(ptr_array_1 ? vhi : vlo, 0, tr, tf);
        V(ptr_o_2) <+ transition(ptr_array_2 ? vhi : vlo, 0, tr, tf);
        V(ptr_o_3) <+ transition(ptr_array_3 ? vhi : vlo, 0, tr, tf);
        V(ptr_o_4) <+ transition(ptr_array_4 ? vhi : vlo, 0, tr, tf);
        V(ptr_o_5) <+ transition(ptr_array_5 ? vhi : vlo, 0, tr, tf);
        V(ptr_o_6) <+ transition(ptr_array_6 ? vhi : vlo, 0, tr, tf);
        V(ptr_o_7) <+ transition(ptr_array_7 ? vhi : vlo, 0, tr, tf);
        V(ptr_o_8) <+ transition(ptr_array_8 ? vhi : vlo, 0, tr, tf);
        V(ptr_o_9) <+ transition(ptr_array_9 ? vhi : vlo, 0, tr, tf);
        V(ptr_o_10) <+ transition(ptr_array_10 ? vhi : vlo, 0, tr, tf);
        V(ptr_o_11) <+ transition(ptr_array_11 ? vhi : vlo, 0, tr, tf);
        V(ptr_o_12) <+ transition(ptr_array_12 ? vhi : vlo, 0, tr, tf);
        V(ptr_o_13) <+ transition(ptr_array_13 ? vhi : vlo, 0, tr, tf);
        V(ptr_o_14) <+ transition(ptr_array_14 ? vhi : vlo, 0, tr, tf);
        V(ptr_o_15) <+ transition(ptr_array_15 ? vhi : vlo, 0, tr, tf);

        V(cell_en_o_0) <+ transition(cell_en_array_0 ? vhi : vlo, 0, tr, tf);
        V(cell_en_o_1) <+ transition(cell_en_array_1 ? vhi : vlo, 0, tr, tf);
        V(cell_en_o_2) <+ transition(cell_en_array_2 ? vhi : vlo, 0, tr, tf);
        V(cell_en_o_3) <+ transition(cell_en_array_3 ? vhi : vlo, 0, tr, tf);
        V(cell_en_o_4) <+ transition(cell_en_array_4 ? vhi : vlo, 0, tr, tf);
        V(cell_en_o_5) <+ transition(cell_en_array_5 ? vhi : vlo, 0, tr, tf);
        V(cell_en_o_6) <+ transition(cell_en_array_6 ? vhi : vlo, 0, tr, tf);
        V(cell_en_o_7) <+ transition(cell_en_array_7 ? vhi : vlo, 0, tr, tf);
        V(cell_en_o_8) <+ transition(cell_en_array_8 ? vhi : vlo, 0, tr, tf);
        V(cell_en_o_9) <+ transition(cell_en_array_9 ? vhi : vlo, 0, tr, tf);
        V(cell_en_o_10) <+ transition(cell_en_array_10 ? vhi : vlo, 0, tr, tf);
        V(cell_en_o_11) <+ transition(cell_en_array_11 ? vhi : vlo, 0, tr, tf);
        V(cell_en_o_12) <+ transition(cell_en_array_12 ? vhi : vlo, 0, tr, tf);
        V(cell_en_o_13) <+ transition(cell_en_array_13 ? vhi : vlo, 0, tr, tf);
        V(cell_en_o_14) <+ transition(cell_en_array_14 ? vhi : vlo, 0, tr, tf);
        V(cell_en_o_15) <+ transition(cell_en_array_15 ? vhi : vlo, 0, tr, tf);
    end
endmodule
