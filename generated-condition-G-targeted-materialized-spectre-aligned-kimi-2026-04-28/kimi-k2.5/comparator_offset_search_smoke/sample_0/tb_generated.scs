simulator lang=spectre
global 0

ahdl_include "comparator_offset_search_ref.va"

// Power supply
Vdd (vdd 0) vsource dc=1.8
Vss (vss 0) vsource dc=0

// Reference input (inn) at 0.5V
Vinn (inn 0) vsource dc=0.5

// Input ramp: sweep inp from 0 to 1V over 100ns
Vinp (inp 0) vsource type=pwl wave=[0 0 100n 1.0]

// DUT instance
XDUT (vdd vss inp inn outp) comparator_offset_search_ref

// Transient analysis
tran tran stop=100n maxstep=100p errpreset=conservative

// Save statements for required observables
save inp inn outp
