`include "constants.vams"
`include "disciplines.vams"

module sample_hold (vdd, vss, in, clk, out);
    inout vdd, vss;
    input in, clk;
    output out;
    electrical vdd, vss, in, clk, out;

    parameter real vth = 0.45 from (0:inf);
    parameter real tedge = 100p from (0:inf);

    real held_value;
    real out_target;
    integer initialized;

    analog begin
        @(initial_step) begin
            held_value = 0.0;
            initialized = 0;
        end

        @(cross(V(clk) - vth, 1)) begin
            held_value = V(in);
            initialized = 1;
        end

        out_target = initialized ? held_value : 0.0;
        V(out) <+ transition(out_target, 0, tedge);
    end
endmodule
