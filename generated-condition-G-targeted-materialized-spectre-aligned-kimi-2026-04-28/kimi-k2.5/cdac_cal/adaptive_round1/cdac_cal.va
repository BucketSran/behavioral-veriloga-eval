`include "constants.vams"
`include "disciplines.vams"

module cdac_cal (VDD, VSS, CLK, D9, D8, D7, D6, D5, D4, D3, D2, D1, D0, CAL0, CAL1, VDAC_P, VDAC_N);
    inout VDD, VSS;
    input CLK, D9, D8, D7, D6, D5, D4, D3, D2, D1, D0, CAL0, CAL1;
    output VDAC_P, VDAC_N;
    electrical VDD, VSS, CLK, D9, D8, D7, D6, D5, D4, D3, D2, D1, D0, CAL0, CAL1, VDAC_P, VDAC_N;

    // Parameters
    parameter real vdd_level = 1.8;
    parameter real vss_level = 0.0;
    parameter real vth = 0.9;
    parameter real tr = 100p;
    parameter real tf = 100p;
    parameter real td = 0.0;

    // State variables
    integer state;
    real vout_p, vout_n;
    real weight_sum_p, weight_sum_n;
    real clk_val;
    real d9_val, d8_val, d7_val, d6_val, d5_val, d4_val, d3_val, d2_val, d1_val, d0_val;
    real cal0_val, cal1_val;
    real vdd_meas, vss_meas;

    analog begin
        @(initial_step) begin
            state = 0;
            vout_p = vss_level;
            vout_n = vss_level;
        end

        // Measure supply levels dynamically
        vdd_meas = V(VDD);
        vss_meas = V(VSS);

        // Sample input values
        clk_val = V(CLK);
        d9_val = V(D9) > vth ? 1.0 : 0.0;
        d8_val = V(D8) > vth ? 1.0 : 0.0;
        d7_val = V(D7) > vth ? 1.0 : 0.0;
        d6_val = V(D6) > vth ? 1.0 : 0.0;
        d5_val = V(D5) > vth ? 1.0 : 0.0;
        d4_val = V(D4) > vth ? 1.0 : 0.0;
        d3_val = V(D3) > vth ? 1.0 : 0.0;
        d2_val = V(D2) > vth ? 1.0 : 0.0;
        d1_val = V(D1) > vth ? 1.0 : 0.0;
        d0_val = V(D0) > vth ? 1.0 : 0.0;
        cal0_val = V(CAL0) > vth ? 1.0 : 0.0;
        cal1_val = V(CAL1) > vth ? 1.0 : 0.0;

        // Detect clock rising edge for charge redistribution update
        @(cross(V(CLK) - vth, 1)) begin
            state = state + 1;
        end

        // Calculate weighted sum for positive output
        // Binary weighted: D9=512, D8=256, D7=128, D6=64, D5=32, D4=16, D3=8, D2=4, D1=2, D0=1
        // CAL0 and CAL1 are 1 unit each
        // Total capacitance: 1023 (main array) + 2 (cal) = 1025
        weight_sum_p = 512.0 * d9_val + 256.0 * d8_val + 128.0 * d7_val + 64.0 * d6_val +
                       32.0 * d5_val + 16.0 * d4_val + 8.0 * d3_val + 4.0 * d2_val +
                       2.0 * d1_val + 1.0 * d0_val + 1.0 * cal0_val + 1.0 * cal1_val;

        // For differential topology, negative side gets complementary switching
        weight_sum_n = 512.0 * (1.0 - d9_val) + 256.0 * (1.0 - d8_val) + 128.0 * (1.0 - d7_val) +
                       64.0 * (1.0 - d6_val) + 32.0 * (1.0 - d5_val) + 16.0 * (1.0 - d4_val) +
                       8.0 * (1.0 - d3_val) + 4.0 * (1.0 - d2_val) + 2.0 * (1.0 - d1_val) +
                       1.0 * (1.0 - d0_val) + 1.0 * cal1_val + 1.0 * cal0_val;

        // Calculate DAC output voltages based on charge redistribution
        // Use measured supply levels for proper voltage domain output
        vout_p = vss_meas + (vdd_meas - vss_meas) * weight_sum_p / 1025.0;
        vout_n = vss_meas + (vdd_meas - vss_meas) * weight_sum_n / 1025.0;

        // Output with transition for smooth changes
        V(VDAC_P) <+ transition(vout_p, td, tr, tf);
        V(VDAC_N) <+ transition(vout_n, td, tr, tf);
    end
endmodule
