`include "constants.vams"
`include "disciplines.vams"

module lfsr (DPN, VDD, VSS, CLK, EN, RSTB);
    output DPN;
    inout VDD;
    inout VSS;
    input CLK;
    input EN;
    input RSTB;

    electrical DPN;
    electrical VDD;
    electrical VSS;
    electrical CLK;
    electrical EN;
    electrical RSTB;

    parameter real vdd_level = 1.8;
    parameter real vss_level = 0.0;
    parameter real vth = 0.9;
    parameter real tr = 0.1n;
    parameter real tf = 0.1n;
    parameter integer seed = 123;

    integer lfsr_reg;
    integer new_bit;
    integer dpn_val;
    real v_dpn;

    analog begin
        @(initial_step) begin
            lfsr_reg = seed;
            dpn_val = (lfsr_reg >> 30) & 1;
            v_dpn = dpn_val * vdd_level;
        end

        // Reset detection (active low)
        @(cross(V(RSTB) - vth, -1)) begin
            lfsr_reg = seed;
            dpn_val = (lfsr_reg >> 30) & 1;
            v_dpn = dpn_val * vdd_level;
        end

        // Clock rising edge with reset deasserted and enable high
        @(cross(V(CLK) - vth, 1)) begin
            if (V(RSTB) > vth && V(EN) > vth) begin
                // LFSR polynomial: taps at 31, 21, 1, 0 (1-based indexing)
                // Convert to 0-based: bits 30, 20, 0, and new bit is position 0
                // Feedback: bit30 ^ bit20 ^ bit0
                new_bit = ((lfsr_reg >> 30) & 1) ^ ((lfsr_reg >> 20) & 1) ^ (lfsr_reg & 1);
                lfsr_reg = (lfsr_reg << 1) | new_bit;
                // Keep only 31 bits
                lfsr_reg = lfsr_reg & 2147483647; // 0x7FFFFFFF
                dpn_val = (lfsr_reg >> 30) & 1;
                v_dpn = dpn_val * vdd_level;
            end
        end

        V(DPN) <+ transition(v_dpn, 0, tr, tf);
    end
endmodule
