`include "constants.vams"
`include "disciplines.vams"

module timer_absolute_grid_ref (VDD, VSS, clk_out);
    inout VDD, VSS;
    output clk_out;
    electrical VDD, VSS, clk_out;

    parameter real tstart = 10n from (0:inf);
    parameter real tstep = 10n from (0:inf);
    parameter real tedge = 200p from (0:inf);

    integer state;
    real next_t;
    real vhi;
    real vlo;

    analog begin
        @(initial_step) begin
            state = 0;
            next_t = tstart;
            vhi = V(VDD);
            vlo = V(VSS);
        end

        @(timer(next_t)) begin
            state = !state;
            next_t = next_t + tstep;
        end

        V(clk_out) <+ transition(state ? vhi : vlo, 0, tedge);
    end
endmodule
