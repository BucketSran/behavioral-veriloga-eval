`include "constants.vams"
`include "disciplines.vams"

module bbpd_data_edge_alignment_ref (vdd, vss, clk, data, up, dn, retimed_data);
    inout vdd, vss;
    input clk, data;
    output up, dn, retimed_data;
    electrical vdd, vss, clk, data, up, dn, retimed_data;

    // Parameters
    parameter real vhi = 1.8 from (0:inf);
    parameter real vlo = 0.0 from (-inf:inf);
    parameter real vth = 0.9 from (0:inf);
    parameter real tdel = 0.0 from [0:inf);
    parameter real tr = 0.1n from (0:inf);
    parameter real tf = 0.1n from (0:inf);
    parameter real pulse_width = 2.0n from (0:inf);
    parameter real min_sep = 0.5n from (0:inf);

    // State variables
    integer up_state;
    integer dn_state;
    integer retimed_state;
    real last_up_time;
    real last_dn_time;
    real data_edge_time;
    integer data_edge_dir;
    integer data_edge_valid;

    analog begin
        @(initial_step) begin
            up_state = 0;
            dn_state = 0;
            retimed_state = 0;
            last_up_time = -1e9;
            last_dn_time = -1e9;
            data_edge_time = -1e9;
            data_edge_dir = 0;
            data_edge_valid = 0;
        end

        // Detect data edges (both rising and falling)
        @(cross(V(data) - vth, 1)) begin
            data_edge_time = $abstime;
            data_edge_dir = 1;
            data_edge_valid = 1;
        end
        @(cross(V(data) - vth, -1)) begin
            data_edge_time = $abstime;
            data_edge_dir = -1;
            data_edge_valid = 1;
        end

        // Detect clock rising edges - process alignment
        @(cross(V(clk) - vth, 1)) begin
            real clk_time;
            clk_time = $abstime;

            if (data_edge_valid) begin
                // Data edge came before clock edge: data leads, UP pulse
                if (data_edge_time < clk_time) begin
                    if ((clk_time - last_dn_time) > min_sep) begin
                        up_state = 1;
                        last_up_time = clk_time;
                    end
                end
                // Data edge came after clock edge: data lags, DN pulse
                else if (data_edge_time > clk_time) begin
                    if ((clk_time - last_up_time) > min_sep) begin
                        dn_state = 1;
                        last_dn_time = clk_time;
                    end
                end
                data_edge_valid = 0;
            end
            else begin
                // Clock edge with no data edge: data lags, DN pulse
                if ((clk_time - last_up_time) > min_sep) begin
                    dn_state = 1;
                    last_dn_time = clk_time;
                end
            end

            // Update retimed data
            retimed_state = (V(data) > vth) ? 1 : 0;
        end

        // Auto-clear UP pulse after width
        @(timer(last_up_time + pulse_width)) begin
            if (up_state && ($abstime - last_up_time) >= pulse_width) begin
                up_state = 0;
            end
        end

        // Auto-clear DN pulse after width
        @(timer(last_dn_time + pulse_width)) begin
            if (dn_state && ($abstime - last_dn_time) >= pulse_width) begin
                dn_state = 0;
            end
        end

        // Output assignments with transition
        V(up) <+ transition(up_state ? vhi : vlo, tdel, tr, tf);
        V(dn) <+ transition(dn_state ? vhi : vlo, tdel, tr, tf);
        V(retimed_data) <+ transition(retimed_state ? vhi : vlo, tdel, tr, tf);
    end
endmodule
