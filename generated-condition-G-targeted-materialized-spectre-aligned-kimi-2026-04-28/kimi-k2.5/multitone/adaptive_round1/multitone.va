`include "constants.vams"
`include "disciplines.vams"

module multitone (OUT);
    output OUT;
    electrical OUT;

    parameter integer N = 4 from [1:8];
    parameter real freq0 = 1e6;
    parameter real freq1 = 2e6;
    parameter real freq2 = 3e6;
    parameter real freq3 = 4e6;
    parameter real freq4 = 0;
    parameter real freq5 = 0;
    parameter real freq6 = 0;
    parameter real freq7 = 0;
    parameter real amp0 = 1.0;
    parameter real amp1 = 0.5;
    parameter real amp2 = 0.25;
    parameter real amp3 = 0.125;
    parameter real amp4 = 0;
    parameter real amp5 = 0;
    parameter real amp6 = 0;
    parameter real amp7 = 0;

    real max_freq;
    real out_val;
    integer i;

    analog begin
        @(initial_step) begin
            max_freq = 0.0;
            if (freq0 > max_freq) max_freq = freq0;
            if (freq1 > max_freq) max_freq = freq1;
            if (freq2 > max_freq) max_freq = freq2;
            if (freq3 > max_freq) max_freq = freq3;
            if (freq4 > max_freq) max_freq = freq4;
            if (freq5 > max_freq) max_freq = freq5;
            if (freq6 > max_freq) max_freq = freq6;
            if (freq7 > max_freq) max_freq = freq7;
        end

        $bound_step(0.1 / max_freq);

        out_val = 0.0;
        out_val = out_val + amp0 * sin(2.0 * `M_PI * freq0 * $abstime);
        out_val = out_val + amp1 * sin(2.0 * `M_PI * freq1 * $abstime);
        out_val = out_val + amp2 * sin(2.0 * `M_PI * freq2 * $abstime);
        out_val = out_val + amp3 * sin(2.0 * `M_PI * freq3 * $abstime);
        out_val = out_val + amp4 * sin(2.0 * `M_PI * freq4 * $abstime);
        out_val = out_val + amp5 * sin(2.0 * `M_PI * freq5 * $abstime);
        out_val = out_val + amp6 * sin(2.0 * `M_PI * freq6 * $abstime);
        out_val = out_val + amp7 * sin(2.0 * `M_PI * freq7 * $abstime);

        V(OUT) <+ out_val;
    end
endmodule
